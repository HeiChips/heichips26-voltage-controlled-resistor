* Extracted by KLayout with SG13CMOS5L LVS runset on : 28/09/2026 20:32

.SUBCKT vcr_bisection T1 T2 i1_b0 i1_b1 i1_b2 i1_b3 i1_b4 i2_b0 i2_b1 i2_b2
+ i2_b3 i2_b4 i3_b0 i3_b1 i3_b2 i3_b3 i3_b4 vctrl vdd vss
X$40 vss \$2 vdd \$2 T2 \$8 opamp_rtr
X$41 vss vdd \$8 i1_b2 i1_b1 i1_b0 i1_b4 i1_b3 isource_beta
X$45 vss vdd \$26 i2_b2 i2_b1 i2_b0 i2_b4 i2_b3 isource_beta
X$46 vss vdd \$52 i3_b2 i3_b1 i3_b0 i3_b4 i3_b3 isource_beta
X$47 vss \$46 vdd \$85 \$88 \$52 opamp_rtr
X$50 vss \$22 vdd \$22 T1 \$26 opamp_rtr
M$1 T1 T1 T1 vss sg13_hv_nmos L=2u W=15u AS=3.975p AD=3.975p PS=23.56u
+ PD=23.56u rfmode=0
M$2 T1 \$46 T2 vss sg13_hv_nmos L=10u W=15u AS=2.85p AD=2.85p PS=15.76u
+ PD=15.76u rfmode=0
R$24 vss \$46 vss rppd w=1u l=200u ps=0u b=0 m=1
R$44 \$74 vctrl vss rppd w=1u l=200u ps=0u b=0 m=1
R$45 vss vss vss rppd w=1u l=10u ps=0u b=0 m=2
R$50 \$74 \$22 vss rppd w=1u l=50u ps=0u b=0 m=1
R$56 \$2 \$74 vss rppd w=1u l=50u ps=0u b=0 m=1
.ENDS vcr_bisection

.SUBCKT isource_beta vss vdd out b2 b1 b0 b4 b3
M$1 \$2 \$2 \$2 vss sg13_hv_nmos L=0.5u W=100u AS=26.5p AD=26.5p PS=160.6u
+ PD=160.6u rfmode=0
M$2 \$2 \$5 \$22 vss sg13_hv_nmos L=4u W=120u AS=22.8p AD=22.8p PS=129.12u
+ PD=129.12u rfmode=0
M$35 vss vss vss vss sg13_hv_nmos L=0.5u W=20u AS=5.3p AD=5.3p PS=32.12u
+ PD=32.12u rfmode=0
M$36 vss \$5 \$5 vss sg13_hv_nmos L=4u W=40u AS=7.6p AD=7.6p PS=43.04u
+ PD=43.04u rfmode=0
M$57 vdd vdd vdd vdd sg13_hv_pmos L=0.4u W=18u AS=4.77p AD=4.77p PS=30.18u
+ PD=30.18u rfmode=0
M$58 vdd \$2 out vdd sg13_hv_pmos L=4u W=12u AS=2.28p AD=2.28p PS=13.52u
+ PD=13.52u rfmode=0
M$60 vdd \$2 \$5 vdd sg13_hv_pmos L=4u W=12u AS=2.28p AD=2.28p PS=13.52u
+ PD=13.52u rfmode=0
M$64 vdd \$2 \$2 vdd sg13_hv_pmos L=4u W=12u AS=2.28p AD=2.28p PS=13.52u
+ PD=13.52u rfmode=0
M$75 vss vss vss vss sg13_hv_nmos L=0.45u W=26u AS=6.89p AD=6.89p PS=41.12u
+ PD=41.12u rfmode=0
M$76 vss \$5 \$69 vss sg13_hv_nmos L=0.45u W=10u AS=1.9p AD=1.9p PS=10.76u
+ PD=10.76u rfmode=0
M$78 vss \$69 \$2 vss sg13_hv_nmos L=0.45u W=10u AS=1.9p AD=1.9p PS=10.76u
+ PD=10.76u rfmode=0
M$81 \$69 vdd vdd vdd sg13_hv_pmos L=10u W=1u AS=0.34p AD=0.34p PS=2.68u
+ PD=2.68u rfmode=0
M$83 vss b0 \$94 vss sg13_hv_nmos L=0.45u W=16u AS=3.04p AD=3.04p PS=16.76u
+ PD=16.76u rfmode=0
M$84 \$94 b1 \$95 vss sg13_hv_nmos L=0.45u W=16u AS=3.04p AD=3.04p PS=16.76u
+ PD=16.76u rfmode=0
M$85 \$95 b2 \$104 vss sg13_hv_nmos L=0.45u W=16u AS=3.04p AD=3.04p PS=16.76u
+ PD=16.76u rfmode=0
M$86 \$104 b3 \$99 vss sg13_hv_nmos L=0.45u W=16u AS=3.04p AD=3.04p PS=16.76u
+ PD=16.76u rfmode=0
M$87 \$99 b4 \$22 vss sg13_hv_nmos L=0.45u W=16u AS=3.04p AD=3.04p PS=16.76u
+ PD=16.76u rfmode=0
R$94 vss vss vss rppd w=1u l=10u ps=0u b=0 m=2
R$108 \$22 \$99 vss rppd w=1u l=160u ps=0u b=0 m=1
R$117 \$104 \$99 vss rppd w=1u l=80u ps=0u b=0 m=1
R$121 \$95 \$104 vss rppd w=1u l=40u ps=0u b=0 m=1
R$123 \$94 \$95 vss rppd w=1u l=20u ps=0u b=0 m=1
R$125 vss \$94 vss rppd w=1u l=10u ps=0u b=0 m=1
.ENDS isource_beta

.SUBCKT opamp_rtr \$1 out vdd inn inp ibias
M$1 \$37 \$37 \$37 \$1 sg13_hv_nmos L=1u W=5u AS=1.325p AD=1.325p PS=8.56u
+ PD=8.56u rfmode=0
M$2 \$37 \$29 \$10 \$1 sg13_hv_nmos L=1u W=5u AS=0.95p AD=0.95p PS=5.76u
+ PD=5.76u rfmode=0
M$5 \$1 \$1 \$1 \$1 sg13_hv_nmos L=0.45u W=22.5u AS=5.4p AD=5.4p PS=35.76u
+ PD=35.76u rfmode=0
M$6 \$1 ibias \$7 \$1 sg13_hv_nmos L=4u W=5u AS=0.95p AD=0.95p PS=5.76u
+ PD=5.76u rfmode=0
M$8 \$1 ibias ibias \$1 sg13_hv_nmos L=4u W=5u AS=0.95p AD=0.95p PS=5.76u
+ PD=5.76u rfmode=0
M$10 \$1 ibias \$94 \$1 sg13_hv_nmos L=4u W=5u AS=0.95p AD=0.95p PS=5.76u
+ PD=5.76u rfmode=0
M$13 \$1 \$34 \$36 \$1 sg13_hv_nmos L=4u W=5u AS=0.95p AD=0.95p PS=5.76u
+ PD=5.76u rfmode=0
M$15 \$1 \$34 \$34 \$1 sg13_hv_nmos L=4u W=5u AS=0.95p AD=0.95p PS=5.76u
+ PD=5.76u rfmode=0
M$17 \$1 \$34 \$37 \$1 sg13_hv_nmos L=4u W=5u AS=0.95p AD=0.95p PS=5.76u
+ PD=5.76u rfmode=0
M$20 \$1 \$127 \$127 \$1 sg13_hv_nmos L=1u W=5u AS=0.95p AD=0.95p PS=5.76u
+ PD=5.76u rfmode=0
M$21 \$127 \$29 \$29 \$1 sg13_hv_nmos L=1u W=5u AS=0.95p AD=0.95p PS=5.76u
+ PD=5.76u rfmode=0
M$26 \$1 \$37 out \$1 sg13_hv_nmos L=1u W=20u AS=3.8p AD=3.8p PS=23.04u
+ PD=23.04u rfmode=0
M$35 \$94 \$94 \$94 \$1 sg13_hv_nmos L=0.45u W=10u AS=2.65p AD=2.65p PS=18.18u
+ PD=18.18u rfmode=0
M$36 \$94 \$7 \$85 \$1 sg13_hv_nmos L=1u W=5u AS=0.95p AD=0.95p PS=5.76u
+ PD=5.76u rfmode=0
M$40 \$1 \$86 \$86 \$1 sg13_hv_nmos L=4u W=5u AS=0.95p AD=0.95p PS=6.52u
+ PD=6.52u rfmode=0
M$42 \$1 \$86 \$94 \$1 sg13_hv_nmos L=4u W=5u AS=0.95p AD=0.95p PS=6.52u
+ PD=6.52u rfmode=0
M$45 \$1 \$71 \$71 \$1 sg13_hv_nmos L=4u W=5u AS=0.95p AD=0.95p PS=6.52u
+ PD=6.52u rfmode=0
M$47 \$1 \$71 \$37 \$1 sg13_hv_nmos L=4u W=5u AS=0.95p AD=0.95p PS=6.52u
+ PD=6.52u rfmode=0
M$61 \$10 \$10 \$10 vdd sg13_hv_pmos L=1u W=15u AS=3.975p AD=3.975p PS=23.56u
+ PD=23.56u rfmode=0
M$62 \$10 \$36 \$37 vdd sg13_hv_pmos L=1u W=15u AS=2.85p AD=2.85p PS=15.76u
+ PD=15.76u rfmode=0
M$65 vdd vdd vdd vdd sg13_hv_pmos L=0.4u W=60u AS=14.775p AD=14.775p PS=87.88u
+ PD=87.88u rfmode=0
M$66 vdd \$80 \$80 vdd sg13_hv_pmos L=4u W=15u AS=2.85p AD=2.85p PS=16.52u
+ PD=16.52u rfmode=0
M$68 vdd \$80 \$10 vdd sg13_hv_pmos L=4u W=15u AS=2.85p AD=2.85p PS=16.52u
+ PD=16.52u rfmode=0
M$71 vdd \$85 \$85 vdd sg13_hv_pmos L=4u W=15u AS=2.85p AD=2.85p PS=16.52u
+ PD=16.52u rfmode=0
M$73 vdd \$85 \$35 vdd sg13_hv_pmos L=4u W=15u AS=2.85p AD=2.85p PS=16.52u
+ PD=16.52u rfmode=0
M$87 \$35 \$35 \$35 \$35 sg13_hv_pmos L=0.4u W=30u AS=7.95p AD=7.95p PS=48.18u
+ PD=48.18u rfmode=0
M$88 \$35 \$7 \$86 \$35 sg13_hv_pmos L=1u W=15u AS=2.85p AD=2.85p PS=15.76u
+ PD=15.76u rfmode=0
M$92 vdd \$7 \$29 vdd sg13_hv_pmos L=4u W=15u AS=2.85p AD=2.85p PS=15.76u
+ PD=15.76u rfmode=0
M$94 vdd \$7 \$7 vdd sg13_hv_pmos L=4u W=15u AS=2.85p AD=2.85p PS=15.76u
+ PD=15.76u rfmode=0
M$96 vdd \$7 \$10 vdd sg13_hv_pmos L=4u W=15u AS=2.85p AD=2.85p PS=15.76u
+ PD=15.76u rfmode=0
M$98 vdd \$7 \$34 vdd sg13_hv_pmos L=4u W=15u AS=2.85p AD=2.85p PS=15.76u
+ PD=15.76u rfmode=0
M$100 vdd \$7 \$35 vdd sg13_hv_pmos L=4u W=15u AS=2.85p AD=2.85p PS=15.76u
+ PD=15.76u rfmode=0
M$103 vdd \$3 \$3 vdd sg13_hv_pmos L=1u W=15u AS=2.85p AD=2.85p PS=15.76u
+ PD=15.76u rfmode=0
M$104 \$3 \$36 \$36 vdd sg13_hv_pmos L=1u W=15u AS=2.85p AD=2.85p PS=15.76u
+ PD=15.76u rfmode=0
M$109 vdd \$10 out vdd sg13_hv_pmos L=1u W=60u AS=11.4p AD=11.4p PS=63.04u
+ PD=63.04u rfmode=0
M$119 \$94 inn \$80 \$1 sg13_hv_nmos L=2u W=5u AS=0.95p AD=0.95p PS=6.52u
+ PD=6.52u rfmode=0
M$121 \$94 inp \$10 \$1 sg13_hv_nmos L=2u W=5u AS=0.95p AD=0.95p PS=6.52u
+ PD=6.52u rfmode=0
C$130 \$101 out cap_cmomf w=21u l=13.5u A=0p P=0u m=1
R$131 \$1 \$1 \$1 rhigh w=1u l=9u ps=0u b=0 m=2
C$133 \$68 out cap_cmomf w=13.5u l=21u A=0p P=0u m=1
R$136 \$101 \$10 \$1 rhigh w=1u l=36u ps=0u b=0 m=1
R$140 \$37 \$68 \$1 rhigh w=1u l=36u ps=0u b=0 m=1
M$143 \$35 inn \$71 \$35 sg13_hv_pmos L=2u W=15u AS=2.85p AD=2.85p PS=16.52u
+ PD=16.52u rfmode=0
M$145 \$35 inp \$37 \$35 sg13_hv_pmos L=2u W=15u AS=2.85p AD=2.85p PS=16.52u
+ PD=16.52u rfmode=0
.ENDS opamp_rtr
