** sch_path: /home/noah/Documents/freizeit/heichips/heichips26-voltage-controlled-resistor/macros/heichips26_vcr/schematic/xschem/heichips26_vcr.sch
.subckt heichips26_vcr VPWR VAPWR VGND rst_n clk ena uio_in[7] uio_in[6] uio_in[5] uio_in[4] uio_in[3] uio_in[2] uio_in[1]
+ uio_in[0] ui_in[7] ui_in[6] ui_in[5] ui_in[4] ui_in[3] ui_in[2] ui_in[1] ui_in[0] uio_oe[7] uio_oe[6] uio_oe[5] uio_oe[4] uio_oe[3]
+ uio_oe[2] uio_oe[1] uio_oe[0] uio_out[7] uio_out[6] uio_out[5] uio_out[4] uio_out[3] uio_out[2] uio_out[1] uio_out[0] uo_out[7] uo_out[6]
+ uo_out[5] uo_out[4] uo_out[3] uo_out[2] uo_out[1] uo_out[0] analog_2 analog_1 analog_0
*.PININFO rst_n:I clk:I ena:I uio_in[7]:I ui_in[7]:I uio_oe[7]:O uio_oe[6]:O uio_oe[5]:O uio_oe[4]:O uio_oe[3]:O uio_oe[2]:O
*+ uio_oe[1]:O uio_oe[0]:O uio_out[7]:O uio_out[6]:O uio_out[5]:O uio_out[4]:O uio_out[3]:O uio_out[2]:O uio_out[1]:O uio_out[0]:O uo_out[7]:O
*+ uo_out[6]:O uo_out[5]:O uo_out[4]:O uo_out[3]:O uo_out[2]:O uo_out[1]:O uo_out[0]:O VPWR:B VGND:B VAPWR:B ui_in[6]:I ui_in[5]:I ui_in[4]:I
*+ ui_in[3]:I ui_in[2]:I ui_in[1]:I ui_in[0]:I uio_in[6]:I uio_in[5]:I uio_in[4]:I uio_in[3]:I uio_in[2]:I uio_in[1]:I uio_in[0]:I analog_2:B
*+ analog_1:B analog_0:B
*connector(3,1) ?1 rst_n ?1 clk ?1 ena
*connector(8,1) ?1 uio_in[7] ?1 uio_in[6] ?1 uio_in[5] ?1 uio_in[4] ?1 uio_in[3] ?1 uio_in[2] ?1 uio_in[1] ?1 uio_in[0]
*connector(8,1) ?1 ui_in[7] ?1 ui_in[6] ?1 ui_in[5] ?1 ui_in[4] ?1 ui_in[3] ?1 ui_in[2] ?1 ui_in[1] ?1 ui_in[0]
*connector(8,1) ?1 uio_oe[7] ?1 uio_oe[6] ?1 uio_oe[5] ?1 uio_oe[4] ?1 uio_oe[3] ?1 uio_oe[2] ?1 uio_oe[1] ?1 uio_oe[0]
*connector(8,1) ?1 uio_out[7] ?1 uio_out[6] ?1 uio_out[5] ?1 uio_out[4] ?1 uio_out[3] ?1 uio_out[2] ?1 uio_out[1] ?1 uio_out[0]
*connector(8,1) ?1 uo_out[7] ?1 uo_out[6] ?1 uo_out[5] ?1 uo_out[4] ?1 uo_out[3] ?1 uo_out[2] ?1 uo_out[1] ?1 uo_out[0]
*connector(3,1) ?1 VPWR ?1 VAPWR ?1 VGND
*connector(3,1) ?1 analog_2 ?1 analog_1 ?1 analog_0
XM1 VGND VPWR VGND VGND sg13_lv_pmos w=70.0u l=10.0u ng=7 m=1 mm_ok=1
x1 analog_2 VAPWR VGND analog_0 analog_1 uio_in[4] uio_in[7] uio_in[6] uio_in[5] VPWR uio_out[4] switched_cap_cell
x5 VAPWR net2 net1 net3 VGND YadavVCR
x3 net3 analog_2 VAPWR ui_in[0] VGND net2 analog_1 net1 analog_0 analog_switch_3pst
x4 net5 analog_2 VAPWR ui_in[1] VGND analog_1 net12 analog_0 net4 analog_switch_3pst
x43 VSS VGND net_tie
x44 VDD VPWR net_tie
x8 net9 net10 net7 net8 net11 net10 net9 net7 net8 net11 net10 net9 net7 net8 net11 net5 VAPWR VGND net4 net12 vcr_bisection
x9 VAPWR ui_in[3] net10 VGND lvl_shift_up
x10 VAPWR ui_in[4] net9 VGND lvl_shift_up
x11 VAPWR ui_in[5] net8 VGND lvl_shift_up
x17 VAPWR ui_in[2] net11 VGND lvl_shift_up
x41 VAPWR ui_in[6] net7 VGND lvl_shift_up
XM3 VGND VAPWR VGND VGND sg13_hv_pmos w=180u l=10u ng=18 m=1 mm_ok=1
XM2 VGND VAPWR VGND VGND sg13_hv_pmos w=240u l=10u ng=24 m=1 mm_ok=1
XR1 uio_in[3] net6 VGND rsil w=0.5e-6 l=0.5e-6 m=1 mm_ok=1
XR2 uio_in[2] net6 VGND rsil w=0.5e-6 l=0.5e-6 m=1 mm_ok=1
XR3 uio_in[1] net6 VGND rsil w=0.5e-6 l=0.5e-6 m=1 mm_ok=1
XR4 uio_in[0] net6 VGND rsil w=0.5e-6 l=0.5e-6 m=1 mm_ok=1
XR5 ui_in[7] net6 VGND rsil w=0.5e-6 l=0.5e-6 m=1 mm_ok=1
XR6 uio_oe[7] net6 VGND rsil w=0.5e-6 l=0.5e-6 m=1 mm_ok=1
XR7 uio_oe[6] net6 VGND rsil w=0.5e-6 l=0.5e-6 m=1 mm_ok=1
XR8 uio_oe[5] net6 VGND rsil w=0.5e-6 l=0.5e-6 m=1 mm_ok=1
XR9 uio_oe[4] net6 VGND rsil w=0.5e-6 l=0.5e-6 m=1 mm_ok=1
XR10 uio_oe[3] net6 VGND rsil w=0.5e-6 l=0.5e-6 m=1 mm_ok=1
XR11 uio_oe[2] net6 VGND rsil w=0.5e-6 l=0.5e-6 m=1 mm_ok=1
XR12 uio_oe[1] net6 VGND rsil w=0.5e-6 l=0.5e-6 m=1 mm_ok=1
XR13 uio_oe[0] net6 VGND rsil w=0.5e-6 l=0.5e-6 m=1 mm_ok=1
XR14 uio_out[7] net6 VGND rsil w=0.5e-6 l=0.5e-6 m=1 mm_ok=1
XR15 uio_out[6] net6 VGND rsil w=0.5e-6 l=0.5e-6 m=1 mm_ok=1
XR16 uio_out[5] net6 VGND rsil w=0.5e-6 l=0.5e-6 m=1 mm_ok=1
XR18 uio_out[3] net6 VGND rsil w=0.5e-6 l=0.5e-6 m=1 mm_ok=1
XR19 uio_out[2] net6 VGND rsil w=0.5e-6 l=0.5e-6 m=1 mm_ok=1
XR20 uio_out[1] net6 VGND rsil w=0.5e-6 l=0.5e-6 m=1 mm_ok=1
XR21 uio_out[0] net6 VGND rsil w=0.5e-6 l=0.5e-6 m=1 mm_ok=1
XR22 uo_out[7] net6 VGND rsil w=0.5e-6 l=0.5e-6 m=1 mm_ok=1
XR23 uo_out[6] net6 VGND rsil w=0.5e-6 l=0.5e-6 m=1 mm_ok=1
XR24 uo_out[5] net6 VGND rsil w=0.5e-6 l=0.5e-6 m=1 mm_ok=1
XR25 uo_out[4] net6 VGND rsil w=0.5e-6 l=0.5e-6 m=1 mm_ok=1
XR26 uo_out[3] net6 VGND rsil w=0.5e-6 l=0.5e-6 m=1 mm_ok=1
XR27 uo_out[2] net6 VGND rsil w=0.5e-6 l=0.5e-6 m=1 mm_ok=1
XR28 uo_out[1] net6 VGND rsil w=0.5e-6 l=0.5e-6 m=1 mm_ok=1
XR29 uo_out[0] net6 VGND rsil w=0.5e-6 l=0.5e-6 m=1 mm_ok=1
XM4 VGND VAPWR VGND VGND sg13_hv_pmos w=170u l=10u ng=17 m=1 mm_ok=1
XM5 VGND VAPWR VGND VGND sg13_hv_pmos w=40u l=10u ng=4 m=1 mm_ok=1
XM6 VGND VAPWR VGND VGND sg13_hv_pmos w=180u l=10u ng=18 m=1 mm_ok=1
.ends

* expanding   symbol:  switched_cap_cell.sym # of pins=11
** sym_path: /home/noah/Documents/freizeit/heichips/heichips26-voltage-controlled-resistor/macros/heichips26_vcr/macros/switched_capacitor/schematic/xschem/switched_cap_cell.sym
** sch_path: /home/noah/Documents/freizeit/heichips/heichips26-voltage-controlled-resistor/macros/heichips26_vcr/macros/switched_capacitor/schematic/xschem/switched_cap_cell.sch
.subckt switched_cap_cell ctrl VAPWR VGND r2 r1 clkin selA selB en VPWR clkout
*.PININFO r1:B r2:B VAPWR:B VGND:B ctrl:I clkin:I selA:I selB:I en:I clkout:O VPWR:B
x2 out1 r1 c_sw nout1 VAPWR VGND transmission_gate
x6 out2 r2 c_sw nout2 VAPWR VGND transmission_gate
x1 VAPWR net3 net9 VGND net15 net16 net17 osc
x4 net5 VAPWR clk VGND net3 net13 net1 net2 net6 net7 net8 hv_mux4
x5 VAPWR net2 VGND net18 net1 net19 vco
x3 out1 nout1 VAPWR clk VGND out2 nout2 net4 net14 pulse_shaper_en
x7 net11 net10 net5 net6 VAPWR VGND net7 net8 hv_binary_decoder4
* noconn #net19
* noconn #net15
* noconn #net17
* noconn #net16
* noconn #net18
x8 net12 ctrl net9 net7 VAPWR VGND transmission_gate
x9 VAPWR net7 net12 VGND hv_inverter_40u
x10 VAPWR clkin net13 VGND lvl_shift_up
x11 VAPWR selA net10 VGND lvl_shift_up
x12 VAPWR selB net11 VGND lvl_shift_up
x13 VAPWR en net4 VGND lvl_shift_up
x14 VPWR clk clkout VGND hv_inverter_40u
x15 VAPWR net4 net14 VGND hv_inverter_40u
x16 net4 ctrl net1 net14 VAPWR VGND transmission_gate
.ends

* expanding   symbol:  YadavVCR.sym # of pins=5
** sym_path: /home/noah/Documents/freizeit/heichips/heichips26-voltage-controlled-resistor/macros/heichips26_vcr/macros/yadav/schematic/xschem/YadavVCR.sym
** sch_path: /home/noah/Documents/freizeit/heichips/heichips26-voltage-controlled-resistor/macros/heichips26_vcr/macros/yadav/schematic/xschem/YadavVCR.sch
.subckt YadavVCR Vdd Rin Rout Vc Vss
*.PININFO Vc:I Vss:B Vdd:B Rin:I Rout:O
XM3 Vdd Rin net2 Vss sg13_hv_nmos w=0.72u l=4.14u ng=1 m=1 mm_ok=1
XM13 net1 net1 Vdd Vdd sg13_hv_pmos w=10.0u l=2.16u ng=1 m=1 mm_ok=1
XM1 net3 Rin Vss Vss sg13_hv_nmos w=0.72u l=4.14u ng=1 m=1 mm_ok=1
XM5 net1 net2 Vss Vss sg13_hv_nmos w=0.72u l=4.14u ng=1 m=1 mm_ok=1
XM2 net1 Rout Vss Vss sg13_hv_nmos w=0.72u l=4.14u ng=1 m=1 mm_ok=1
XM16 net3 net3 Vdd Vdd sg13_hv_pmos w=10.0u l=2.16u ng=1 m=1 mm_ok=1
XM7 net2 Vc Vss Vss sg13_hv_nmos w=0.72u l=4.14u ng=1 m=1 mm_ok=1
XM6 net3 net6 Vss Vss sg13_hv_nmos w=0.72u l=4.14u ng=1 m=1 mm_ok=1
XM14 net4 net1 Vdd Vdd sg13_hv_pmos w=10.0u l=2.16u ng=1 m=1 mm_ok=1
XM8 net6 Vc Vss Vss sg13_hv_nmos w=0.72u l=4.14u ng=1 m=1 mm_ok=1
XM4 Vdd Rout net6 Vss sg13_hv_nmos w=0.72u l=4.14u ng=1 m=1 mm_ok=1
XM9 net4 net4 Vss Vss sg13_hv_nmos w=0.72u l=2.16u ng=1 m=1 mm_ok=1
XM10 Rin net4 Vss Vss sg13_hv_nmos w=0.72u l=2.16u ng=1 m=1 mm_ok=1
XM17 Rin net3 Vdd Vdd sg13_hv_pmos w=10.0u l=2.16u ng=1 m=1 mm_ok=1
XM18 net5 net3 Vdd Vdd sg13_hv_pmos w=10.0u l=2.16u ng=1 m=1 mm_ok=1
XM11 net5 net5 Vss Vss sg13_hv_nmos w=0.72u l=2.16u ng=1 m=1 mm_ok=1
XM12 Rout net5 Vss Vss sg13_hv_nmos w=0.72u l=2.16u ng=1 m=1 mm_ok=1
XM15 Rout net1 Vdd Vdd sg13_hv_pmos w=10.0u l=2.16u ng=1 m=1 mm_ok=1
.ends

* expanding   symbol:  analog_switch_3pst.sym # of pins=9
** sym_path: /home/noah/Documents/freizeit/heichips/heichips26-voltage-controlled-resistor/macros/heichips26_vcr/schematic/xschem/analog_switch_3pst.sym
** sch_path: /home/noah/Documents/freizeit/heichips/heichips26-voltage-controlled-resistor/macros/heichips26_vcr/schematic/xschem/analog_switch_3pst.sch
.subckt analog_switch_3pst sw1_p2 sw1_p1 VAPWR ctrl VGND sw2_p2 sw2_p1 sw3_p2 sw3_p1
*.PININFO sw1_p1:B ctrl:B VAPWR:B VGND:B sw2_p1:B sw1_p2:B sw2_p2:B sw3_p1:B sw3_p2:B
x6 net2 sw1_p1 sw1_p2 net1 VAPWR VGND transmission_gate
x7 VAPWR net2 net1 VGND hv_inverter_40u
x3 net2 sw2_p1 sw2_p2 net1 VAPWR VGND transmission_gate
x8 VAPWR ctrl net2 VGND lvl_shift_up
x1 net2 sw3_p1 sw3_p2 net1 VAPWR VGND transmission_gate
.ends

* expanding   symbol:  net_tie.sym # of pins=2
** sym_path: /home/noah/Documents/freizeit/heichips/heichips26-voltage-controlled-resistor/macros/heichips26_vcr/schematic/xschem/net_tie.sym
** sch_path: /home/noah/Documents/freizeit/heichips/heichips26-voltage-controlled-resistor/macros/heichips26_vcr/schematic/xschem/net_tie.sch
.subckt net_tie net2 net1
*.PININFO net1:B net2:B
V1 net2 net1 0
.ends

* expanding   symbol:  vcr_bisection.sym # of pins=20
** sym_path: /home/noah/Documents/freizeit/heichips/heichips26-voltage-controlled-resistor/macros/heichips26_vcr/macros/vcr_bisection/schematic/xschem/vcr_bisection.sym
** sch_path: /home/noah/Documents/freizeit/heichips/heichips26-voltage-controlled-resistor/macros/heichips26_vcr/macros/vcr_bisection/schematic/xschem/vcr_bisection.sch
.subckt vcr_bisection i3_b2 i3_b1 i3_b4 i3_b3 i1_b0 i1_b1 i1_b2 i1_b4 i1_b3 i2_b0 i2_b1 i2_b2 i2_b4 i2_b3 i3_b0 Vctrl Vdd Vss T2
+ T1
*.PININFO T1:I T2:I Vctrl:I Vdd:I Vss:I i1_b0:I i1_b1:I i1_b2:I i1_b4:I i1_b3:I i2_b0:I i2_b1:I i2_b2:I i2_b4:I i2_b3:I i3_b0:I
*+ i3_b1:I i3_b2:I i3_b4:I i3_b3:I
x4 ib3 Vss vgate Vctrl Vdd Vcm voltage_sum
XM1 T2 vgate T1 Vss sg13_hv_nmos w=15u l=10u ng=2 m=1 mm_ok=1
x1 Vdd T1 Vss net1 ib2 net1 opamp_rtr
x2 Vdd T2 Vss net2 ib1 net2 opamp_rtr
x3 i3_b0 Vdd i3_b1 ib3 i3_b2 i3_b3 Vss i3_b4 isource_beta
x5 i2_b0 Vdd i2_b1 ib2 i2_b2 i2_b3 Vss i2_b4 isource_beta
x6 i1_b0 Vdd i1_b1 ib1 i1_b2 i1_b3 Vss i1_b4 isource_beta
XR4 Vcm net1 vss rppd w=1e-6 l=50e-6 m=1 b=0 mm_ok=1
XR1 net2 Vcm vss rppd w=1e-6 l=50e-6 m=1 b=0 mm_ok=1
XR2 Vss Vss vss rppd w=1e-6 l=10e-6 m=2 b=0 mm_ok=1
XM2 T1 T1 T1 Vss sg13_hv_nmos w=15u l=2u ng=2 m=1 mm_ok=1
.ends

* expanding   symbol:  lvl_shift_up.sym # of pins=4
** sym_path: /home/noah/Documents/freizeit/heichips/heichips26-voltage-controlled-resistor/macros/heichips26_vcr/macros/switched_capacitor/schematic/xschem/lvl_shift_up.sym
** sch_path: /home/noah/Documents/freizeit/heichips/heichips26-voltage-controlled-resistor/macros/heichips26_vcr/macros/switched_capacitor/schematic/xschem/lvl_shift_up.sch
.subckt lvl_shift_up VDD in out VSS
*.PININFO in:I VDD:B VSS:B out:O
XM1 net1 in VSS VSS sg13_hv_nmos w={n_ng*n_w} l={n_l} ng={n_ng} m=1 mm_ok=1
XM2 net1 in VDD VDD sg13_hv_pmos w={p_ng*p_w} l={p_l} ng={n_ng} m=1 mm_ok=1
**** begin user architecture code

.include ../../../macros/switched_capacitor/schematic/xschem/hv_inverter_6u5.sym

.param n_ng = 2
.param n_w = 10u
.param n_l = 0.45u
.param p_ng = 2
.param p_w = 1u
.param p_l = 0.45u

**** end user architecture code
x4 VDD net1 out VSS hv_inverter_6u5
.ends

* expanding   symbol:  transmission_gate.sym # of pins=6
** sym_path: /home/noah/Documents/freizeit/heichips/heichips26-voltage-controlled-resistor/macros/heichips26_vcr/macros/switched_capacitor/schematic/xschem/transmission_gate.sym
** sch_path: /home/noah/Documents/freizeit/heichips/heichips26-voltage-controlled-resistor/macros/heichips26_vcr/macros/switched_capacitor/schematic/xschem/transmission_gate.sch
.subckt transmission_gate vctrl vin vout nvctrl VDD VSS
*.PININFO vin:B vout:B vctrl:I nvctrl:I VDD:B VSS:B
XM3 vout vctrl vin VSS sg13_hv_nmos w={tg_ngate_w*tg_ng} l={tg_ch_len} ng={tg_ng} m=1 mm_ok=1
XM4 vout nvctrl vin VDD sg13_hv_pmos w={tg_pgate_w*tg_ng} l={tg_ch_len} ng={tg_ng} m=1 mm_ok=1
**** begin user architecture code

.param tg_ch_len=0.45u
.param tg_ngate_w=2u
.param tg_pgate_w=5u
.param tg_ng=20

**** end user architecture code
.ends

* expanding   symbol:  osc.sym # of pins=7
** sym_path: /home/noah/Documents/freizeit/heichips/heichips26-voltage-controlled-resistor/macros/heichips26_vcr/macros/switched_capacitor/schematic/xschem/osc.sym
** sch_path: /home/noah/Documents/freizeit/heichips/heichips26-voltage-controlled-resistor/macros/heichips26_vcr/macros/switched_capacitor/schematic/xschem/osc.sch
.subckt osc VDD out1 ictrl VSS c1 out2 c2
*.PININFO VSS:B VDD:B out2:B out1:B c2:B ictrl:B c1:B
XM3 out1 ictrl VDD VDD sg13_hv_pmos w=10.0u l=2.0u ng=1 m=1 mm_ok=1
XM2 c1 ictrl VDD VDD sg13_hv_pmos w=1u l=2.0u ng=1 m=1 mm_ok=1
XM4 c2 ictrl VDD VDD sg13_hv_pmos w=1.0u l=2.0u ng=1 m=1 mm_ok=1
XM5 out2 ictrl VDD VDD sg13_hv_pmos w=10.0u l=2.0u ng=1 m=1 mm_ok=1
XM6 ictrl ictrl VDD VDD sg13_hv_pmos w=10.0u l=2.0u ng=1 m=1 mm_ok=1
XM8 out1 c2 VSS VSS sg13_hv_nmos w=3u l=0.45u ng=1 m=1 mm_ok=1
XM1 c2 c2 VSS VSS sg13_hv_nmos w=1u l=2u ng=1 m=1 mm_ok=1
XM12 out2 c1 VSS VSS sg13_hv_nmos w=3u l=0.45u ng=1 m=1 mm_ok=1
XM11 c1 c1 VSS VSS sg13_hv_nmos w=1u l=2u ng=1 m=1 mm_ok=1
**** begin user architecture code

.ic v(out1)=0 v(out2)=3.3

**** end user architecture code
.ends

* expanding   symbol:  hv_mux4.sym # of pins=11
** sym_path: /home/noah/Documents/freizeit/heichips/heichips26-voltage-controlled-resistor/macros/heichips26_vcr/macros/switched_capacitor/schematic/xschem/hv_mux4.sym
** sch_path: /home/noah/Documents/freizeit/heichips/heichips26-voltage-controlled-resistor/macros/heichips26_vcr/macros/switched_capacitor/schematic/xschem/hv_mux4.sch
.subckt hv_mux4 nsel1 VDD out VSS in3 in1 in4 in2 nsel2 nsel3 nsel4
*.PININFO in1:I VDD:B VSS:B out:O in2:I in3:I in4:I nsel1:I nsel3:I nsel2:I nsel4:I
x1 VDD net2 out net1 VSS net3 net4 hv_nor4
x2 VDD nsel1 net2 in1 VSS hv_nor
x4 VDD nsel2 net1 in2 VSS hv_nor
x5 VDD nsel3 net3 in3 VSS hv_nor
x6 VDD nsel4 net4 in4 VSS hv_nor
.ends

* expanding   symbol:  vco.sym # of pins=6
** sym_path: /home/noah/Documents/freizeit/heichips/heichips26-voltage-controlled-resistor/macros/heichips26_vcr/macros/switched_capacitor/schematic/xschem/vco.sym
** sch_path: /home/noah/Documents/freizeit/heichips/heichips26-voltage-controlled-resistor/macros/heichips26_vcr/macros/switched_capacitor/schematic/xschem/vco.sch
.subckt vco VDD out VSS nout vctrl vc
*.PININFO VSS:B VDD:B nout:B out:B vctrl:B vc:B
**** begin user architecture code

.ic v(vc)=1.65

**** end user architecture code
XM4 vc out 5uA- VSS sg13_hv_nmos w=0.3u l=0.45u ng=1 m=1 mm_ok=1
x1 VDD s out nout r VSS hv_rs-ff
**** begin user architecture code

.param cm_n_w = 6u
.param cm_n_l = 5u
.param cm_p_w = 10u
.param cm_p_l = 2u

.param inv_ng = 1
.param inv_n_w = 2u
.param inv_n_l = 0.45u
.param inv_p_w = 6.5u
.param inv_p_l = 0.4u

**** end user architecture code
XM6 vc out 5uA+ VDD sg13_hv_pmos w=0.3u l=0.4u ng=1 m=1 mm_ok=1
x5 net2 vc vthl VDD 40uA- VSS comp_pmos
x7 net1 vthh vc VDD 40uA+ VSS comp_nmos
x2 10uA- vthl VDD vctrl VSS vthh voltage_mirror_pmos
x3 VDD net1 s VSS hv_inverter_6u5
x6 VDD net2 r VSS hv_inverter_6u5
x8 40uA+ 5uA+ VDD VSS 5uA- 10uA- 40uA- bias_current_generator
.ends

* expanding   symbol:  pulse_shaper_en.sym # of pins=9
** sym_path: /home/noah/Documents/freizeit/heichips/heichips26-voltage-controlled-resistor/macros/heichips26_vcr/macros/switched_capacitor/schematic/xschem/pulse_shaper_en.sym
** sch_path: /home/noah/Documents/freizeit/heichips/heichips26-voltage-controlled-resistor/macros/heichips26_vcr/macros/switched_capacitor/schematic/xschem/pulse_shaper_en.sch
.subckt pulse_shaper_en out1 nout1 VDD in VSS out2 nout2 en dis
*.PININFO out1:O nout1:O out2:O nout2:O in:I VSS:B VDD:B en:I dis:I
x7 VDD net1 net3 VSS low_th_inverter
x8 VDD net1 net2 VSS high_th_inverter
x10 VDD out1 nout1 VSS hv_inverter_40u
x11 VDD nout2 out2 VSS hv_inverter_40u
**** begin user architecture code

.include ../../../netlist/pex/hv_inverter_0u3_magic_pex_3.spice
.param w   = 0.3u
.param ng  = 1
.param n_ng = ng
.param n_w = {w*n_ng}
.param n_l = 0.45u
.param p_ng = ng
.param p_w = {1*w*p_ng}
.param p_l = 0.4u

**** end user architecture code
x1 VDD in net1 VSS hv_inverter_0u3
x5 VDD net2 out1 dis VSS hv_nor
x4 VDD net3 nout2 en VSS hv_nand
.ends

* expanding   symbol:  hv_binary_decoder4.sym # of pins=8
** sym_path: /home/noah/Documents/freizeit/heichips/heichips26-voltage-controlled-resistor/macros/heichips26_vcr/macros/switched_capacitor/schematic/xschem/hv_binary_decoder4.sym
** sch_path: /home/noah/Documents/freizeit/heichips/heichips26-voltage-controlled-resistor/macros/heichips26_vcr/macros/switched_capacitor/schematic/xschem/hv_binary_decoder4.sch
.subckt hv_binary_decoder4 msb lsb nout1 nout2 VDD VSS nout3 nout4
*.PININFO VDD:B VSS:B msb:I lsb:I nout1:O nout2:O nout3:O nout4:O
x3 VDD msb net1 VSS hv_inverter_40u
x7 VDD msb nout4 lsb VSS hv_nand
x9 VDD net1 nout2 lsb VSS hv_nand
x10 VDD lsb net2 VSS hv_inverter_40u
x11 VDD msb nout3 net2 VSS hv_nand
x8 VDD net1 nout1 net2 VSS hv_nand
.ends

* expanding   symbol:  hv_inverter_40u.sym # of pins=4
** sym_path: /home/noah/Documents/freizeit/heichips/heichips26-voltage-controlled-resistor/macros/heichips26_vcr/macros/switched_capacitor/schematic/xschem/hv_inverter_40u.sym
** sch_path: /home/noah/Documents/freizeit/heichips/heichips26-voltage-controlled-resistor/macros/heichips26_vcr/macros/switched_capacitor/schematic/xschem/hv_inverter_40u.sch
.subckt hv_inverter_40u VDD in out VSS
*.PININFO in:I VDD:B VSS:B out:O
XM2 out in VSS VSS sg13_hv_nmos w={n_w} l={n_l} ng={ng} m=1 mm_ok=1
XM3 out in VDD VDD sg13_hv_pmos w={p_w} l={p_l} ng={ng} m=1 mm_ok=1
**** begin user architecture code

.param w   = 10u
.param ng  = 4
.param n_ng = ng
.param n_w = {3u*n_ng}
.param n_l = 0.45u
.param p_ng = ng
.param p_w = {10u*p_ng}
.param p_l = 0.4u

**** end user architecture code
.ends

* expanding   symbol:  voltage_sum.sym # of pins=6
** sym_path: /home/noah/Documents/freizeit/heichips/heichips26-voltage-controlled-resistor/macros/heichips26_vcr/macros/vcr_bisection/schematic/xschem/voltage_sum.sym
** sch_path: /home/noah/Documents/freizeit/heichips/heichips26-voltage-controlled-resistor/macros/heichips26_vcr/macros/vcr_bisection/schematic/xschem/voltage_sum.sch
.subckt voltage_sum ibias vss vout vin1 vdd vin2
*.PININFO vin1:B vout:B vin2:B vss:B vdd:B ibias:B
x1 vdd net2 vss net1 ibias vout opamp_rtr
XR4 net2 vin1 vss rppd w=1e-6 l=100e-6 m=1 b=0 mm_ok=1
XR1 net2 vin2 vss rppd w=1e-6 l=100e-6 m=1 b=0 mm_ok=1
XR2 vout net1 vss rppd w=1e-6 l=100e-6 m=1 b=0 mm_ok=1
XR3 vss net1 vss rppd w=1e-6 l=100e-6 m=1 b=0 mm_ok=1
.ends

* expanding   symbol:  ../../macros/opamp_rtr/schematic/xschem/opamp_rtr.sym # of pins=6
** sym_path: /home/noah/Documents/freizeit/heichips/heichips26-voltage-controlled-resistor/macros/heichips26_vcr/macros/vcr_bisection/schematic/xschem/../../macros/opamp_rtr/schematic/xschem/opamp_rtr.sym
** sch_path: /home/noah/Documents/freizeit/heichips/heichips26-voltage-controlled-resistor/macros/heichips26_vcr/macros/vcr_bisection/schematic/xschem/../../macros/opamp_rtr/schematic/xschem/opamp_rtr.sch
.subckt opamp_rtr vdd inp vss inn ibias out
*.PININFO inp:I out:O vdd:B inn:I ibias:I vss:B
XXM6 out1_n inp ncmdiff_n vss sg13_hv_nmos w={w_diff_n} l={l_diff} ng={n_diff_n} m=1 mm_ok=1
XXM1 net1 inn ncmdiff_p ncmdiff_p sg13_hv_pmos w={w_diff_p} l={l_diff} ng={n_diff_p} m=1 mm_ok=1
XXM2 ncmdiff_p inp out1_p ncmdiff_p sg13_hv_pmos w={w_diff_p} l={l_diff} ng={n_diff_p} m=1 mm_ok=1
XXM3 ncmdiff_p vbias_p vdd vdd sg13_hv_pmos w={w_tail_p} l={l_bias} ng={n_tail_p} m=1 mm_ok=1
XXM4 vss net1 net1 vss sg13_hv_nmos w={w_load_n} l={l_load} ng={n_load_n} m=1 mm_ok=1
XXM5 out1_p net1 vss vss sg13_hv_nmos w={w_load_n} l={l_load} ng={n_load_n} m=1 mm_ok=1
XXM7 ncmdiff_n inn net2 vss sg13_hv_nmos w={w_diff_n} l={l_diff} ng={n_diff_n} m=1 mm_ok=1
XXM8 ncmdiff_n ibias vss vss sg13_hv_nmos w={w_tail_n} l={l_bias} ng={n_tail_n} m=1 mm_ok=1
XXM9 vdd net2 out1_n vdd sg13_hv_pmos w={w_load_p} l={l_load} ng={n_load_p} m=1 mm_ok=1
XXM10 net2 net2 vdd vdd sg13_hv_pmos w={w_load_p} l={l_load} ng={n_load_p} m=1 mm_ok=1
XXM25 nswa vbias_p ncmdiff_p ncmdiff_p sg13_hv_pmos w={w_sw_p} l={l_sw} ng={n_sw_p} m=1 mm_ok=1
XXM26 nswa nswa vss vss sg13_hv_nmos w={w_gmn} l={l_bias} ng={n_gmn} m=1 mm_ok=1
XXM27 ncmdiff_n nswa vss vss sg13_hv_nmos w={w_gmn} l={l_bias} ng={n_gmn} m=1 mm_ok=1
XXM28 ncmdiff_n vbias_p nswb vss sg13_hv_nmos w={w_sw_n} l={l_sw} ng={n_sw_n} m=1 mm_ok=1
XXM29 nswb nswb vdd vdd sg13_hv_pmos w={w_gmp} l={l_bias} ng={n_gmp} m=1 mm_ok=1
XXM30 ncmdiff_p nswb vdd vdd sg13_hv_pmos w={w_gmp} l={l_bias} ng={n_gmp} m=1 mm_ok=1
XXM13 out1_n nabn out1_p vss sg13_hv_nmos w={w_ab_n} l={l_ab} ng={n_ab_n} m=1 mm_ok=1
XXM14 out1_p nabp out1_n vdd sg13_hv_pmos w={w_ab_p} l={l_ab} ng={n_ab_p} m=1 mm_ok=1
XXM15 out1_n vbias_p vdd vdd sg13_hv_pmos w={w_ab_src} l={l_bias} ng={n_ab_src} m=1 mm_ok=1
XXM16 out1_p nab_ref vss vss sg13_hv_nmos w={w_ab_snk} l={l_bias} ng={n_ab_snk} m=1 mm_ok=1
XXM23 nab_ref vbias_p vdd vdd sg13_hv_pmos w={w_ab_src} l={l_bias} ng={n_ab_src} m=1 mm_ok=1
XXM24 nab_ref nab_ref vss vss sg13_hv_nmos w={w_ab_snk} l={l_bias} ng={n_ab_snk} m=1 mm_ok=1
XXM17 nabn vbias_p vdd vdd sg13_hv_pmos w={w_ab_src} l={l_bias} ng={n_ab_src} m=1 mm_ok=1
XXM18 nabn nabn net3 vss sg13_hv_nmos w={w_ab_n} l={l_ab} ng={n_ab_n} m=1 mm_ok=1
XXM19 net3 net3 vss vss sg13_hv_nmos w={w_ab_n} l={l_ab} ng={n_ab_n} m=1 mm_ok=1
XXM20 nabp nab_ref vss vss sg13_hv_nmos w={w_ab_snk} l={l_bias} ng={n_ab_snk} m=1 mm_ok=1
XXM21 nabp nabp net4 vdd sg13_hv_pmos w={w_ab_p} l={l_ab} ng={n_ab_p} m=1 mm_ok=1
XXM22 net4 net4 vdd vdd sg13_hv_pmos w={w_ab_p} l={l_ab} ng={n_ab_p} m=1 mm_ok=1
XXM11 out out1_n vdd vdd sg13_hv_pmos w={w_out_p} l={l_out} ng={n_out_p} m=1 mm_ok=1
XXM12 out out1_p vss vss sg13_hv_nmos w={w_out_n} l={l_out} ng={n_out_n} m=1 mm_ok=1
XXB1 ibias ibias vss vss sg13_hv_nmos w={w_bias_n} l={l_bias} ng={n_bias_n} m=1 mm_ok=1
XXB2 vbias_p ibias vss vss sg13_hv_nmos w={w_bias_n} l={l_bias} ng={n_bias_n} m=1 mm_ok=1
XXB3 vbias_p vbias_p vdd vdd sg13_hv_pmos w={w_bias_p} l={l_bias} ng={n_bias_p} m=1 mm_ok=1
**** begin user architecture code

*bias network
.param l_bias=4u
.param w_bias_p=15u
.param n_bias_p=2
.param w_bias_n=5u
.param n_bias_n=2
.param w_ref_n=5u
.param n_ref_n=4
.param w_ref_p=15u
.param n_ref_p=4
*first stage
.param l_diff=2u
.param l_load=4u

.param w_diff_n=5u
.param n_diff_n=4

.param w_diff_p=15u
.param n_diff_p=4

.param w_load_n=5u
.param n_load_n=4

.param w_load_p=15u
.param n_load_p=4

.param w_tail_n=5u
.param n_tail_n=2

.param w_tail_p=15u
.param n_tail_p=2

.param l_sw=1u
.param w_sw_p=15u
.param n_sw_p=2

.param w_sw_n=5u
.param n_sw_n=2

.param w_gmn=5u
.param n_gmn=4

.param w_gmp=15u
.param n_gmp=4

*output control circuit
.param w_ab_src=15u
.param n_ab_src=2
.param w_ab_snk=5u
.param n_ab_snk=2

.param w_ab_n=5u
.param n_ab_n=2
.param w_ab_p=15u
.param n_ab_p=2

.param l_ab=1u

.param w_out_p=60u
.param n_out_p=8
.param w_out_n=20u
.param n_out_n=8
.param l_out=1u

.param r_null=50k
.param c_null=500f

**** end user architecture code
XR4 net5 out1_n vss rhigh w=1e-6 l=36e-6 m=1 b=0 mm_ok=1
XR2 net6 out1_p vss rhigh w=1e-6 l=36e-6 m=1 b=0 mm_ok=1
XDUMMY1 ncmdiff_n ncmdiff_n ncmdiff_n vss sg13_hv_nmos w=5u l=0.45u ng=4 m=1 mm_ok=1
XDUMMY2 ncmdiff_n ncmdiff_n ncmdiff_n vss sg13_hv_nmos w=5u l=0.45u ng=2 m=1 mm_ok=1
XDUMMY10 out1_n out1_n out1_n vdd sg13_hv_pmos w=15u l=1u ng=2 m=1 mm_ok=1
XDUMMY11 out1_p out1_p out1_p vss sg13_hv_nmos w=5u l=1u ng=2 m=1 mm_ok=1
XRDUMMY vss vss vss rhigh w=1e-6 l=9e-6 m=2 b=0 mm_ok=1
XDUMMY3 ncmdiff_p ncmdiff_p ncmdiff_p ncmdiff_p sg13_hv_pmos w=30u l=0.4u ng=6 m=1 mm_ok=1
XDUMMY4 vss vss vss vss sg13_hv_nmos w=22.5u l=0.45u ng=12 m=1 mm_ok=1
XDUMMY5 vdd vdd vdd vdd sg13_hv_pmos w=60u l=0.4u ng=11 m=1 mm_ok=1
.ends

* expanding   symbol:  ../../macros/isource_beta/schematic/xschem/isource_beta.sym # of pins=8
** sym_path: /home/noah/Documents/freizeit/heichips/heichips26-voltage-controlled-resistor/macros/heichips26_vcr/macros/vcr_bisection/schematic/xschem/../../macros/isource_beta/schematic/xschem/isource_beta.sym
** sch_path: /home/noah/Documents/freizeit/heichips/heichips26-voltage-controlled-resistor/macros/heichips26_vcr/macros/vcr_bisection/schematic/xschem/../../macros/isource_beta/schematic/xschem/isource_beta.sch
.subckt isource_beta b0 vdd b1 out b2 b3 vss b4
*.PININFO out:O vdd:B vss:B b0:B b1:B b2:B b3:B b4:B
XM1 net1 v0 vdd vdd sg13_hv_pmos w=12u l=4u ng=4 m=1 mm_ok=1
XM2 v0 v0 vdd vdd sg13_hv_pmos w=12u l=4u ng=4 m=1 mm_ok=1
XM3 net1 net1 vss vss sg13_hv_nmos w=40u l=4u ng=8 m=1 mm_ok=1
XM4 v0 net1 iref vss sg13_hv_nmos w=40u l=4u ng=8 m=3 mm_ok=1
XM5 out v0 vdd vdd sg13_hv_pmos w=12u l=4u ng=4 m=1 mm_ok=1
XMS1 net2 vdd vdd vdd sg13_hv_pmos w=1u l=10u ng=1 m=1 mm_ok=1
XMS2 net2 net1 vss vss sg13_hv_nmos w=10u l=0.45u ng=2 m=1 mm_ok=1
XMS3 v0 net2 vss vss sg13_hv_nmos w=10u l=0.45u ng=2 m=1 mm_ok=1
XR10 iref net4 vss rppd w=1e-6 l=160e-6 m=1 b=0 mm_ok=1
XR2 net6 vss vss rppd w=1e-6 l=10e-6 m=1 b=0 mm_ok=1
XM6 iref b4 net4 vss sg13_hv_nmos w=16u l=0.45u ng=2 m=1 mm_ok=1
XR3 net5 net6 vss rppd w=1e-6 l=20e-6 m=1 b=0 mm_ok=1
XR4 net3 net5 vss rppd w=1e-6 l=40e-6 m=1 b=0 mm_ok=1
XR5 net4 net3 vss rppd w=1e-6 l=80e-6 m=1 b=0 mm_ok=1
XM7 net4 b3 net3 vss sg13_hv_nmos w=16u l=0.45u ng=2 m=1 mm_ok=1
XM8 net3 b2 net5 vss sg13_hv_nmos w=16u l=0.45u ng=2 m=1 mm_ok=1
XM9 net5 b1 net6 vss sg13_hv_nmos w=16u l=0.45u ng=2 m=1 mm_ok=1
XM10 net6 b0 vss vss sg13_hv_nmos w=16u l=0.45u ng=2 m=1 mm_ok=1
XM11 v0 v0 v0 vss sg13_hv_nmos w=100u l=0.5u ng=20 m=1 mm_ok=1
XM12 vss vss vss vss sg13_hv_nmos w=26u l=0.45u ng=4 m=1 mm_ok=1
XR1 vss vss vss rppd w=1e-6 l=10e-6 m=2 b=0 mm_ok=1
XM13 vss vss vss vss sg13_hv_nmos w=20u l=0.5u ng=4 m=1 mm_ok=1
XMS4 vdd vdd vdd vdd sg13_hv_pmos w=18u l=0.4u ng=6 m=1 mm_ok=1
.ends

* expanding   symbol:  hv_inverter_6u5.sym # of pins=4
** sym_path: /home/noah/Documents/freizeit/heichips/heichips26-voltage-controlled-resistor/macros/heichips26_vcr/macros/switched_capacitor/schematic/xschem/hv_inverter_6u5.sym
** sch_path: /home/noah/Documents/freizeit/heichips/heichips26-voltage-controlled-resistor/macros/heichips26_vcr/macros/switched_capacitor/schematic/xschem/hv_inverter_6u5.sch
.subckt hv_inverter_6u5 VDD in out VSS
*.PININFO in:I VDD:B VSS:B out:O
XM2 out in VSS VSS sg13_hv_nmos w={n_w} l={n_l} ng={ng} m=1 mm_ok=1
XM3 out in VDD VDD sg13_hv_pmos w={p_w} l={p_l} ng={ng} m=1 mm_ok=1
**** begin user architecture code

.param ng  = 1
.param n_ng = ng
.param n_w = {2u*n_ng}
.param n_l = 0.45u
.param p_ng = ng
.param p_w = {6.5u*p_ng}
.param p_l = 0.4u

**** end user architecture code
.ends

* expanding   symbol:  hv_nor4.sym # of pins=7
** sym_path: /home/noah/Documents/freizeit/heichips/heichips26-voltage-controlled-resistor/macros/heichips26_vcr/macros/switched_capacitor/schematic/xschem/hv_nor4.sym
** sch_path: /home/noah/Documents/freizeit/heichips/heichips26-voltage-controlled-resistor/macros/heichips26_vcr/macros/switched_capacitor/schematic/xschem/hv_nor4.sch
.subckt hv_nor4 VDD in1 out in2 VSS in3 in4
*.PININFO in1:I VDD:B VSS:B out:O in2:I in3:I in4:I
**** begin user architecture code

.param w   = 10u
.param ng  = 4
.param n_ng = ng
.param n_w = {3u*n_ng}
.param n_l = 0.45u
.param p_ng = ng
.param p_w = {10u*p_ng}
.param p_l = 0.4u

**** end user architecture code
XM2 out in3 VSS VSS sg13_hv_nmos w={n_w} l={n_l} ng={ng} m=1 mm_ok=1
XM3 net3 in4 VDD VDD sg13_hv_pmos w={p_w} l={p_l} ng={ng} m=1 mm_ok=1
XM1 out in4 VSS VSS sg13_hv_nmos w={n_w} l={n_l} ng={ng} m=1 mm_ok=1
XM4 out in1 net1 VDD sg13_hv_pmos w={p_w} l={p_l} ng={ng} m=1 mm_ok=1
XM5 out in2 VSS VSS sg13_hv_nmos w={n_w} l={n_l} ng={ng} m=1 mm_ok=1
XM6 out in1 VSS VSS sg13_hv_nmos w={n_w} l={n_l} ng={ng} m=1 mm_ok=1
XM7 net1 in2 net2 VDD sg13_hv_pmos w={p_w} l={p_l} ng={ng} m=1 mm_ok=1
XM8 net2 in3 net3 VDD sg13_hv_pmos w={p_w} l={p_l} ng={ng} m=1 mm_ok=1
.ends

* expanding   symbol:  hv_nor.sym # of pins=5
** sym_path: /home/noah/Documents/freizeit/heichips/heichips26-voltage-controlled-resistor/macros/heichips26_vcr/macros/switched_capacitor/schematic/xschem/hv_nor.sym
** sch_path: /home/noah/Documents/freizeit/heichips/heichips26-voltage-controlled-resistor/macros/heichips26_vcr/macros/switched_capacitor/schematic/xschem/hv_nor.sch
.subckt hv_nor VDD in1 out in2 VSS
*.PININFO in1:I VDD:B VSS:B out:O in2:I
**** begin user architecture code

.param w   = 10u
.param ng  = 4
.param n_ng = ng
.param n_w = {3u*n_ng}
.param n_l = 0.45u
.param p_ng = ng
.param p_w = {10u*p_ng}
.param p_l = 0.4u

**** end user architecture code
XM2 out in1 VSS VSS sg13_hv_nmos w={n_w} l={n_l} ng={ng} m=1 mm_ok=1
XM3 net1 in2 VDD VDD sg13_hv_pmos w={p_w} l={p_l} ng={ng} m=1 mm_ok=1
XM1 out in2 VSS VSS sg13_hv_nmos w={n_w} l={n_l} ng={ng} m=1 mm_ok=1
XM4 out in1 net1 VDD sg13_hv_pmos w={p_w} l={p_l} ng={ng} m=1 mm_ok=1
.ends

* expanding   symbol:  hv_rs-ff.sym # of pins=6
** sym_path: /home/noah/Documents/freizeit/heichips/heichips26-voltage-controlled-resistor/macros/heichips26_vcr/macros/switched_capacitor/schematic/xschem/hv_rs-ff.sym
** sch_path: /home/noah/Documents/freizeit/heichips/heichips26-voltage-controlled-resistor/macros/heichips26_vcr/macros/switched_capacitor/schematic/xschem/hv_rs-ff.sch
.subckt hv_rs-ff VDD nS Q nQ nR VSS
*.PININFO nS:I VDD:B VSS:B Q:O nR:I nQ:O
x4 VDD nS Q nQ VSS hv_nand
x5 VDD Q nQ nR VSS hv_nand
.ends

* expanding   symbol:  comp_pmos.sym # of pins=6
** sym_path: /home/noah/Documents/freizeit/heichips/heichips26-voltage-controlled-resistor/macros/heichips26_vcr/macros/switched_capacitor/schematic/xschem/comp_pmos.sym
** sch_path: /home/noah/Documents/freizeit/heichips/heichips26-voltage-controlled-resistor/macros/heichips26_vcr/macros/switched_capacitor/schematic/xschem/comp_pmos.sch
.subckt comp_pmos out - + VDD Ibias VSS
*.PININFO VDD:B VSS:B Ibias:I out:O +:I -:I
**** begin user architecture code

.param n_w = 1.2u
.param n_l = 1.5u
.param p_w = 2u
.param p_l = 0.4u
.param bcm = 1

**** end user architecture code
XM9 net1 Ibias VDD VDD sg13_hv_pmos w=bcm*p_w l=p_l ng=1 m=1 mm_ok=1
XM10 out Ibias VDD VDD sg13_hv_pmos w=bcm*p_w l=p_l ng=1 m=1 mm_ok=1
XM11 Ibias Ibias VDD VDD sg13_hv_pmos w=p_w l=p_l ng=1 m=1 mm_ok=1
XM12 net3 + net1 VDD sg13_hv_pmos w=p_w l=p_l ng=1 m=1 mm_ok=1
XM13 net2 - net1 VDD sg13_hv_pmos w=p_w l=p_l ng=1 m=1 mm_ok=1
XM14 net3 net2 VSS VSS sg13_hv_nmos w=n_w l=n_l ng=1 m=1 mm_ok=1
XM15 net2 net2 VSS VSS sg13_hv_nmos w=n_w l=n_l ng=1 m=1 mm_ok=1
XM16 out net3 VSS VSS sg13_hv_nmos w=n_w l=n_l ng=1 m=1 mm_ok=1
.ends

* expanding   symbol:  comp_nmos.sym # of pins=6
** sym_path: /home/noah/Documents/freizeit/heichips/heichips26-voltage-controlled-resistor/macros/heichips26_vcr/macros/switched_capacitor/schematic/xschem/comp_nmos.sym
** sch_path: /home/noah/Documents/freizeit/heichips/heichips26-voltage-controlled-resistor/macros/heichips26_vcr/macros/switched_capacitor/schematic/xschem/comp_nmos.sch
.subckt comp_nmos out - + VDD Ibias VSS
*.PININFO VDD:B VSS:B -:I +:I Ibias:I out:O
XM8 net2 + net3 VSS sg13_hv_nmos w=n_w l=n_l ng=1 m=1 mm_ok=1
XM6 net1 net1 VDD VDD sg13_hv_pmos w=p_w l=p_l ng=1 m=1 mm_ok=1
XM1 net2 net1 VDD VDD sg13_hv_pmos w=p_w l=p_l ng=1 m=1 mm_ok=1
XM3 net1 - net3 VSS sg13_hv_nmos w=n_w l=n_l ng=1 m=1 mm_ok=1
**** begin user architecture code

.param n_w = 1.2u
.param n_l = 1.5u
.param p_w = 2u
.param p_l = 0.4u

**** end user architecture code
XM2 out net2 VDD VDD sg13_hv_pmos w=p_w l=p_l ng=1 m=1 mm_ok=1
XM4 net3 Ibias VSS VSS sg13_hv_nmos w=2*n_w l=n_l ng=1 m=1 mm_ok=1
XM5 out Ibias VSS VSS sg13_hv_nmos w=2*n_w l=n_l ng=1 m=1 mm_ok=1
XM7 Ibias Ibias VSS VSS sg13_hv_nmos w=n_w l=n_l ng=1 m=1 mm_ok=1
.ends

* expanding   symbol:  voltage_mirror_pmos.sym # of pins=6
** sym_path: /home/noah/Documents/freizeit/heichips/heichips26-voltage-controlled-resistor/macros/heichips26_vcr/macros/switched_capacitor/schematic/xschem/voltage_mirror_pmos.sym
** sch_path: /home/noah/Documents/freizeit/heichips/heichips26-voltage-controlled-resistor/macros/heichips26_vcr/macros/switched_capacitor/schematic/xschem/voltage_mirror_pmos.sch
.subckt voltage_mirror_pmos Ibias nout VDD in VSS out
*.PININFO VDD:B VSS:B in:I out:O nout:O Ibias:I
**** begin user architecture code

.param n_w = 6u
.param n_l = 5u
.param p_w = 10u
.param p_l = 2u

**** end user architecture code
XR1 in Ibias VSS rhigh w=0.5e-6 l=34e-6 m=1 b=0 mm_ok=1
XM4 net1 Ibias VDD VDD sg13_hv_pmos w=p_w l=p_l ng=1 m=1 mm_ok=1
XM5 out net1 VSS VSS sg13_hv_nmos w=n_w l=n_l ng=1 m=1 mm_ok=1
XR2 VSS nout VSS rhigh w=0.5e-6 l=34e-6 m=1 b=0 mm_ok=1
XR3 out VDD VSS rhigh w=0.5e-6 l=34e-6 m=1 b=0 mm_ok=1
XM2 net1 net1 VSS VSS sg13_hv_nmos w=n_w l=n_l ng=1 m=1 mm_ok=1
XM3 nout Ibias VDD VDD sg13_hv_pmos w=p_w l=p_l ng=1 m=1 mm_ok=1
XM6 Ibias Ibias VDD VDD sg13_hv_pmos w=1.9*p_w l=p_l ng=1 m=1 mm_ok=1
.ends

* expanding   symbol:  bias_current_generator.sym # of pins=7
** sym_path: /home/noah/Documents/freizeit/heichips/heichips26-voltage-controlled-resistor/macros/heichips26_vcr/macros/switched_capacitor/schematic/xschem/bias_current_generator.sym
** sch_path: /home/noah/Documents/freizeit/heichips/heichips26-voltage-controlled-resistor/macros/heichips26_vcr/macros/switched_capacitor/schematic/xschem/bias_current_generator.sch
.subckt bias_current_generator 40uA+ 5uA+ VDD VSS 5uA- 10uA- 40uA-
*.PININFO 40uA+:O VSS:B VDD:B 40uA-:O 10uA-:O 5uA+:O 5uA-:O
x4 VDD net1 VSS current_reference_40uA
XM11 net1 net1 VDD VDD sg13_hv_pmos w=cm_p_w l=cm_p_l ng=1 m=1 mm_ok=1
XM12 40uA+ net1 VDD VDD sg13_hv_pmos w=cm_p_w l=cm_p_l ng=1 m=1 mm_ok=1
XM13 net2 net1 VDD VDD sg13_hv_pmos w=cm_p_w l=cm_p_l ng=1 m=1 mm_ok=1
XM14 net2 net2 VSS VSS sg13_hv_nmos w=cm_n_w l=cm_n_l ng=1 m=1 mm_ok=1
XM15 40uA- net2 VSS VSS sg13_hv_nmos w=cm_n_w l=cm_n_l ng=1 m=1 mm_ok=1
XM1 net3 net1 VDD VDD sg13_hv_pmos w=cm_p_w l=cm_p_l ng=1 m=1 mm_ok=1
XM2 net3 net3 VSS VSS sg13_hv_nmos w=4*cm_n_w l=cm_n_l ng=4 m=1 mm_ok=1
XM3 10uA- net3 VSS VSS sg13_hv_nmos w=cm_n_w l=cm_n_l ng=1 m=1 mm_ok=1
XM5 net4 net3 VSS VSS sg13_hv_nmos w=cm_n_w l=cm_n_l ng=1 m=1 mm_ok=1
XM25 net4 net4 VDD VDD sg13_hv_pmos w=2*cm_p_w l=cm_p_l ng=2 m=1 mm_ok=1
XM26 net5 net4 VDD VDD sg13_hv_pmos w=cm_p_w l=cm_p_l ng=1 m=1 mm_ok=1
XM27 5uA+ net4 VDD VDD sg13_hv_pmos w=cm_p_w l=cm_p_l ng=1 m=1 mm_ok=1
XM28 net5 net5 VSS VSS sg13_hv_nmos w=cm_n_w l=cm_n_l ng=2 m=1 mm_ok=1
XM29 5uA- net5 VSS VSS sg13_hv_nmos w=cm_n_w l=cm_n_l ng=1 m=1 mm_ok=1
**** begin user architecture code

.param cm_n_w = 6u
.param cm_n_l = 5u
.param cm_p_w = 10u
.param cm_p_l = 2u

**** end user architecture code
.ends

* expanding   symbol:  low_th_inverter.sym # of pins=4
** sym_path: /home/noah/Documents/freizeit/heichips/heichips26-voltage-controlled-resistor/macros/heichips26_vcr/macros/switched_capacitor/schematic/xschem/low_th_inverter.sym
** sch_path: /home/noah/Documents/freizeit/heichips/heichips26-voltage-controlled-resistor/macros/heichips26_vcr/macros/switched_capacitor/schematic/xschem/low_th_inverter.sch
.subckt low_th_inverter VDD vin vout VSS
*.PININFO vin:I VDD:B VSS:B vout:O
XM1 vout vin VSS VSS sg13_hv_nmos w={n_ng*n_w} l={n_l} ng={n_ng} m=1 mm_ok=1
XM2 vout vin VDD VDD sg13_hv_pmos w={p_ng*p_w} l={p_l} ng={n_ng} m=1 mm_ok=1
**** begin user architecture code

.param n_ng = 2
.param n_w = 1u
.param n_l = 0.45u
.param p_ng = 2
.param p_w = 1u
.param p_l = 0.4u

**** end user architecture code
.ends

* expanding   symbol:  high_th_inverter.sym # of pins=4
** sym_path: /home/noah/Documents/freizeit/heichips/heichips26-voltage-controlled-resistor/macros/heichips26_vcr/macros/switched_capacitor/schematic/xschem/high_th_inverter.sym
** sch_path: /home/noah/Documents/freizeit/heichips/heichips26-voltage-controlled-resistor/macros/heichips26_vcr/macros/switched_capacitor/schematic/xschem/high_th_inverter.sch
.subckt high_th_inverter VDD vin vout VSS
*.PININFO vin:I VDD:B VSS:B vout:O
**** begin user architecture code

.param n_ng = 2
.param n_w = 1u
.param n_l = 0.45u
.param p_ng = 2
.param p_w = 10u
.param p_l = 0.4u

**** end user architecture code
XM1 vout vin VSS VSS sg13_hv_nmos w={n_ng*n_w} l={n_l} ng={p_ng} m=1 mm_ok=1
XM2 vout vin VDD VDD sg13_hv_pmos w={p_ng*p_w} l={p_l} ng={p_ng} m=1 mm_ok=1
.ends

* expanding   symbol:  hv_inverter_0u3.sym # of pins=4
** sym_path: /home/noah/Documents/freizeit/heichips/heichips26-voltage-controlled-resistor/macros/heichips26_vcr/macros/switched_capacitor/schematic/xschem/hv_inverter_0u3.sym
** sch_path: /home/noah/Documents/freizeit/heichips/heichips26-voltage-controlled-resistor/macros/heichips26_vcr/macros/switched_capacitor/schematic/xschem/hv_inverter_0u3.sch
.subckt hv_inverter_0u3 VDD in out VSS
*.PININFO in:I VDD:B VSS:B out:O
XM2 out in VSS VSS sg13_hv_nmos w={n_w} l={n_l} ng={ng} m=1 mm_ok=1
XM3 out in VDD VDD sg13_hv_pmos w={p_w} l={p_l} ng={ng} m=1 mm_ok=1
**** begin user architecture code

.param w   = 0.3u
.param ng  = 1
.param n_ng = ng
.param n_w = {w*n_ng}
.param n_l = 0.45u
.param p_ng = ng
.param p_w = {1*w*p_ng}
.param p_l = 0.4u

**** end user architecture code
.ends

* expanding   symbol:  hv_nand.sym # of pins=5
** sym_path: /home/noah/Documents/freizeit/heichips/heichips26-voltage-controlled-resistor/macros/heichips26_vcr/macros/switched_capacitor/schematic/xschem/hv_nand.sym
** sch_path: /home/noah/Documents/freizeit/heichips/heichips26-voltage-controlled-resistor/macros/heichips26_vcr/macros/switched_capacitor/schematic/xschem/hv_nand.sch
.subckt hv_nand VDD in1 out in2 VSS
*.PININFO in1:I VDD:B VSS:B out:O in2:I
**** begin user architecture code

.param w   = 10u
.param ng  = 4
.param n_ng = ng
.param n_w = {3u*n_ng}
.param n_l = 0.45u
.param p_ng = ng
.param p_w = {10u*p_ng}
.param p_l = 0.4u

**** end user architecture code
XM2 out in1 net1 VSS sg13_hv_nmos w={n_w} l={n_l} ng={ng} m=1 mm_ok=1
XM3 out in2 VDD VDD sg13_hv_pmos w={p_w} l={p_l} ng={ng} m=1 mm_ok=1
XM1 net1 in2 VSS VSS sg13_hv_nmos w={n_w} l={n_l} ng={ng} m=1 mm_ok=1
XM4 out in1 VDD VDD sg13_hv_pmos w={p_w} l={p_l} ng={ng} m=1 mm_ok=1
.ends

* expanding   symbol:  current_reference_40uA.sym # of pins=3
** sym_path: /home/noah/Documents/freizeit/heichips/heichips26-voltage-controlled-resistor/macros/heichips26_vcr/macros/switched_capacitor/schematic/xschem/current_reference_40uA.sym
** sch_path: /home/noah/Documents/freizeit/heichips/heichips26-voltage-controlled-resistor/macros/heichips26_vcr/macros/switched_capacitor/schematic/xschem/current_reference_40uA.sch
.subckt current_reference_40uA VDD iout VSS
*.PININFO VSS:B VDD:B iout:B
XM8 net2 net2 VSS VSS sg13_hv_nmos w=n_w l=n_l ng=1 m=1 mm_ok=1
XM6 net2 net1 VDD VDD sg13_hv_pmos w=p_w l=p_l ng=1 m=1 mm_ok=1
XM1 net1 net1 VDD VDD sg13_hv_pmos w=p_w l=p_l ng=1 m=1 mm_ok=1
XM3 net1 net2 net3 VSS sg13_hv_nmos w=n_w l=n_l ng=1 m=1 mm_ok=1
XR2 net4 VSS VSS rppd w=2e-6 l=21.9e-6 m=1 b=0 mm_ok=1
XM2 net1 net2 net3 VSS sg13_hv_nmos w=n_w l=n_l ng=1 m=1 mm_ok=1
XM4 net1 net2 net3 VSS sg13_hv_nmos w=n_w l=n_l ng=1 m=1 mm_ok=1
XM5 net1 net2 net3 VSS sg13_hv_nmos w=n_w l=n_l ng=1 m=1 mm_ok=1
XM7 iout net2 VSS VSS sg13_hv_nmos w=n_w l=n_l ng=1 m=1 mm_ok=1
XR3 net3 net4 VSS rsil w=0.5e-6 l=365e-6 m=1 mm_ok=1
**** begin user architecture code

.param n_w = 6u
.param n_l = 5u
.param p_w = 10u
.param p_l = 2u

**** end user architecture code
.ends
