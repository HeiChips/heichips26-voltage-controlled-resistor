** sch_path: /home/noah/Documents/freizeit/heichips/heichips26-voltage-controlled-resistor/macros/heichips26_vcr/schematic/xschem/heichips26_analog_project.sch
.subckt heichips26_analog_project VPWR VAPWR VGND rst_n clk ena uio_in[7] uio_in[6] uio_in[5] uio_in[4] uio_in[3] uio_in[2]
+ uio_in[1] uio_in[0] ui_in[7] ui_in[6] ui_in[5] ui_in[4] ui_in[3] ui_in[2] ui_in[1] ui_in[0] uio_oe[7] uio_oe[6] uio_oe[5] uio_oe[4]
+ uio_oe[3] uio_oe[2] uio_oe[1] uio_oe[0] uio_out[7] uio_out[6] uio_out[5] uio_out[4] uio_out[3] uio_out[2] uio_out[1] uio_out[0] uo_out[7]
+ uo_out[6] uo_out[5] uo_out[4] uo_out[3] uo_out[2] uo_out[1] uo_out[0] analog_2 analog_1 analog_0
*.PININFO rst_n:I clk:I ena:I uio_in[7]:I ui_in[7]:I uio_oe[7]:O uio_oe[6]:O uio_oe[5]:O uio_oe[4]:O uio_oe[3]:O uio_oe[2]:O
*+ uio_oe[1]:O uio_oe[0]:O uio_out[7]:O uio_out[6]:O uio_out[5]:O uio_out[4]:O uio_out[3]:O uio_out[2]:O uio_out[1]:O uio_out[0]:O uo_out[7]:O
*+ uo_out[6]:O uo_out[5]:O uo_out[4]:O uo_out[3]:O uo_out[2]:O uo_out[1]:O uo_out[0]:O VPWR:B VGND:B VAPWR:B ui_in[6]:I ui_in[5]:I ui_in[4]:I
*+ ui_in[3]:I ui_in[2]:I ui_in[1]:I ui_in[0]:I uio_in[6]:I uio_in[5]:I uio_in[4]:I uio_in[3]:I uio_in[2]:I uio_in[1]:I uio_in[0]:I analog_2:B
*+ analog_1:B analog_0:B
*connector(3,1) ?1 rst_n ?1 clk ?1 ena
*connector(8,1) ?1 uio_in[7] ?1 uio_in[6] ?1 uio_in[5] ?1 uio_in[4] ?1 uio_in[3] ?1 uio_in[2] ?1 uio_in[1] ?1 uio_in[0]
*connector(8,1) ?1 ui_in[7] ?1 ui_in[6] ?1 ui_in[5] ?1 ui_in[4] ?1 ui_in[3] ?1 ui_in[2] ?1 ui_in[1] ?1 ui_in[0]
*connector(8,1) ?1 uio_oe[7] ?1 uio_oe[6] ?1 uio_oe[5] ?1 uio_oe[4] ?1 uio_oe[3] ?1 uio_oe[2] ?1 uio_oe[1] ?1 uio_oe[0]
*connector(8,1) ?1 uio_out[7] ?1 uio_out[6] ?1 uio_out[5] ?1 uio_out[4] ?1 uio_out[3] ?1 uio_out[2] ?1 uio_out[1] ?1 uio_out[0]
*connector(8,1) ?1 uo_out[7] ?1 uo_out[6] ?1 uo_out[5] ?1 uo_out[4] ?1 uo_out[3] ?1 uo_out[2] ?1 uo_out[1] ?1 uo_out[0]
*connector(3,1) ?1 VPWR ?1 VAPWR ?1 VGND
*connector(3,1) ?1 analog_2 ?1 analog_1 ?1 analog_0
x1 analog_0 VAPWR VGND analog_2 analog_1 ui_in[4] ui_in[7] ui_in[6] ui_in[5] VPWR uo_out[7] switched_cap_cell
x5 VAPWR net2 net1 net3 VGND YadavVCR
x3 net3 analog_0 VAPWR ui_in[3] VGND net2 analog_1 net1 analog_2 analog_switch_3pst
.ends

* expanding   symbol:  switched_cap_cell.sym # of pins=11
** sym_path: /home/noah/Documents/freizeit/heichips/heichips26-voltage-controlled-resistor/macros/heichips26_vcr/macros/switched_capacitor/schematic/xschem/switched_cap_cell.sym
** sch_path: /home/noah/Documents/freizeit/heichips/heichips26-voltage-controlled-resistor/macros/heichips26_vcr/macros/switched_capacitor/schematic/xschem/switched_cap_cell.sch
.subckt switched_cap_cell ctrl VAPWR VGND r2 r1 clkin selA selB en VPWR clkout
*.PININFO r1:B r2:B VAPWR:B VGND:B ctrl:I clkin:I selA:I selB:I en:I clkout:O VPWR:B
x2 out1 r1 c_sw nout1 VAPWR VGND transmission_gate
x6 out2 r2 c_sw nout2 VAPWR VGND transmission_gate
x1 VAPWR net3 net9 VGND net15 net16 net17 osc
x4 net5 VAPWR clk VGND net3 net13 net1 net2 net6 net7 net8 hv_mux4
x5 VAPWR net2 VGND net18 net1 net19 vco
x3 out1 nout1 VAPWR clk VGND out2 nout2 net4 net14 pulse_shaper_en
x7 net11 net10 net5 net6 VAPWR VGND net7 net8 hv_binary_decoder4
* noconn #net19
* noconn #net15
* noconn #net17
* noconn #net16
* noconn #net18
x8 net12 ctrl net9 net7 VAPWR VGND transmission_gate
x9 VAPWR net7 net12 VGND hv_inverter_40u
x10 VAPWR clkin net13 VGND lvl_shift_up
x11 VAPWR selA net10 VGND lvl_shift_up
x12 VAPWR selB net11 VGND lvl_shift_up
x13 VAPWR en net4 VGND lvl_shift_up
x14 VPWR clk clkout VGND hv_inverter_40u
x15 VAPWR net4 net14 VGND hv_inverter_40u
x16 net4 ctrl net1 net14 VAPWR VGND transmission_gate
.ends

* expanding   symbol:  YadavVCR.sym # of pins=5
** sym_path: /home/noah/Documents/freizeit/heichips/heichips26-voltage-controlled-resistor/macros/heichips26_vcr/macros/yadav/schematic/xschem/YadavVCR.sym
** sch_path: /home/noah/Documents/freizeit/heichips/heichips26-voltage-controlled-resistor/macros/heichips26_vcr/macros/yadav/schematic/xschem/YadavVCR.sch
.subckt YadavVCR Vdd Rin Rout Vc Vss
*.PININFO Vc:I Vss:B Vdd:B Rin:I Rout:O
MM3 Vdd Rin net2 Vss sg13_hv_nmos w=0.72u l=4.14u ng=1
MM13 net1 net1 Vdd Vdd sg13_hv_pmos w=10.0u l=2.16u ng=1
MM1 net3 Rin Vss Vss sg13_hv_nmos w=0.72u l=4.14u ng=1
MM5 net1 net2 Vss Vss sg13_hv_nmos w=0.72u l=4.14u ng=1
MM2 net1 Rout Vss Vss sg13_hv_nmos w=0.72u l=4.14u ng=1
MM16 net3 net3 Vdd Vdd sg13_hv_pmos w=10.0u l=2.16u ng=1
MM7 net2 Vc Vss Vss sg13_hv_nmos w=0.72u l=4.14u ng=1
MM6 net3 net6 Vss Vss sg13_hv_nmos w=0.72u l=4.14u ng=1
MM14 net4 net1 Vdd Vdd sg13_hv_pmos w=10.0u l=2.16u ng=1
MM8 net6 Vc Vss Vss sg13_hv_nmos w=0.72u l=4.14u ng=1
MM4 Vdd Rout net6 Vss sg13_hv_nmos w=0.72u l=4.14u ng=1
MM9 net4 net4 Vss Vss sg13_hv_nmos w=0.72u l=2.16u ng=1
MM10 Rin net4 Vss Vss sg13_hv_nmos w=0.72u l=2.16u ng=1
MM17 Rin net3 Vdd Vdd sg13_hv_pmos w=10.0u l=2.16u ng=1
MM18 net5 net3 Vdd Vdd sg13_hv_pmos w=10.0u l=2.16u ng=1
MM11 net5 net5 Vss Vss sg13_hv_nmos w=0.72u l=2.16u ng=1
MM12 Rout net5 Vss Vss sg13_hv_nmos w=0.72u l=2.16u ng=1
MM15 Rout net1 Vdd Vdd sg13_hv_pmos w=10.0u l=2.16u ng=1
.ends

* expanding   symbol:  analog_switch_3pst.sym # of pins=9
** sym_path: /home/noah/Documents/freizeit/heichips/heichips26-voltage-controlled-resistor/macros/heichips26_vcr/schematic/xschem/analog_switch_3pst.sym
** sch_path: /home/noah/Documents/freizeit/heichips/heichips26-voltage-controlled-resistor/macros/heichips26_vcr/schematic/xschem/analog_switch_3pst.sch
.subckt analog_switch_3pst sw1_p2 sw1_p1 VAPWR ctrl VGND sw2_p2 sw2_p1 sw3_p2 sw3_p1
*.PININFO sw1_p1:B ctrl:B VAPWR:B VGND:B sw2_p1:B sw1_p2:B sw2_p2:B sw3_p1:B sw3_p2:B
x6 net2 sw1_p1 sw1_p2 net1 VAPWR VGND transmission_gate
x7 VAPWR net2 net1 VGND hv_inverter_40u
x3 net2 sw2_p1 sw2_p2 net1 VAPWR VGND transmission_gate
x8 VAPWR ctrl net2 VGND lvl_shift_up
x1 net2 sw3_p1 sw3_p2 net1 VAPWR VGND transmission_gate
.ends

* expanding   symbol:  transmission_gate.sym # of pins=6
** sym_path: /home/noah/Documents/freizeit/heichips/heichips26-voltage-controlled-resistor/macros/heichips26_vcr/macros/switched_capacitor/schematic/xschem/transmission_gate.sym
** sch_path: /home/noah/Documents/freizeit/heichips/heichips26-voltage-controlled-resistor/macros/heichips26_vcr/macros/switched_capacitor/schematic/xschem/transmission_gate.sch
.subckt transmission_gate vctrl vin vout nvctrl VDD VSS
*.PININFO vin:B vout:B vctrl:I nvctrl:I VDD:B VSS:B
MM3 vout vctrl vin VSS sg13_hv_nmos w={tg_ngate_w*tg_ng} l={tg_ch_len} ng={tg_ng}
MM4 vout nvctrl vin VDD sg13_hv_pmos w={tg_pgate_w*tg_ng} l={tg_ch_len} ng={tg_ng}
**** begin user architecture code

.param tg_ch_len=0.45u
.param tg_ngate_w=2u
.param tg_pgate_w=5u
.param tg_ng=20

**** end user architecture code
.ends

* expanding   symbol:  osc.sym # of pins=7
** sym_path: /home/noah/Documents/freizeit/heichips/heichips26-voltage-controlled-resistor/macros/heichips26_vcr/macros/switched_capacitor/schematic/xschem/osc.sym
** sch_path: /home/noah/Documents/freizeit/heichips/heichips26-voltage-controlled-resistor/macros/heichips26_vcr/macros/switched_capacitor/schematic/xschem/osc.sch
.subckt osc VDD out1 ictrl VSS c1 out2 c2
*.PININFO VSS:B VDD:B out2:B out1:B c2:B ictrl:B c1:B
MM3 out1 ictrl VDD VDD sg13_hv_pmos w=10.0u l=2.0u ng=1
MM2 c1 ictrl VDD VDD sg13_hv_pmos w=1u l=2.0u ng=1
MM4 c2 ictrl VDD VDD sg13_hv_pmos w=1.0u l=2.0u ng=1
MM5 out2 ictrl VDD VDD sg13_hv_pmos w=10.0u l=2.0u ng=1
MM6 ictrl ictrl VDD VDD sg13_hv_pmos w=10.0u l=2.0u ng=1
MM8 out1 c2 VSS VSS sg13_hv_nmos w=3u l=0.45u ng=1
MM1 c2 c2 VSS VSS sg13_hv_nmos w=1u l=2u ng=1
MM12 out2 c1 VSS VSS sg13_hv_nmos w=3u l=0.45u ng=1
MM11 c1 c1 VSS VSS sg13_hv_nmos w=1u l=2u ng=1
**** begin user architecture code

.ic v(out1)=0 v(out2)=3.3

**** end user architecture code
.ends

* expanding   symbol:  hv_mux4.sym # of pins=11
** sym_path: /home/noah/Documents/freizeit/heichips/heichips26-voltage-controlled-resistor/macros/heichips26_vcr/macros/switched_capacitor/schematic/xschem/hv_mux4.sym
** sch_path: /home/noah/Documents/freizeit/heichips/heichips26-voltage-controlled-resistor/macros/heichips26_vcr/macros/switched_capacitor/schematic/xschem/hv_mux4.sch
.subckt hv_mux4 nsel1 VDD out VSS in3 in1 in4 in2 nsel2 nsel3 nsel4
*.PININFO in1:I VDD:B VSS:B out:O in2:I in3:I in4:I nsel1:I nsel3:I nsel2:I nsel4:I
x1 VDD net2 out net1 VSS net3 net4 hv_nor4
x2 VDD nsel1 net2 in1 VSS hv_nor
x4 VDD nsel2 net1 in2 VSS hv_nor
x5 VDD nsel3 net3 in3 VSS hv_nor
x6 VDD nsel4 net4 in4 VSS hv_nor
.ends

* expanding   symbol:  vco.sym # of pins=6
** sym_path: /home/noah/Documents/freizeit/heichips/heichips26-voltage-controlled-resistor/macros/heichips26_vcr/macros/switched_capacitor/schematic/xschem/vco.sym
** sch_path: /home/noah/Documents/freizeit/heichips/heichips26-voltage-controlled-resistor/macros/heichips26_vcr/macros/switched_capacitor/schematic/xschem/vco.sch
.subckt vco VDD out VSS nout vctrl vc
*.PININFO VSS:B VDD:B nout:B out:B vctrl:B vc:B
**** begin user architecture code

.ic v(vc)=1.65

**** end user architecture code
MM4 vc out 5uA- VSS sg13_hv_nmos w=0.3u l=0.45u ng=1
x1 VDD s out nout r VSS hv_rs-ff
**** begin user architecture code

.param cm_n_w = 6u
.param cm_n_l = 5u
.param cm_p_w = 10u
.param cm_p_l = 2u

.param inv_ng = 1
.param inv_n_w = 2u
.param inv_n_l = 0.45u
.param inv_p_w = 6.5u
.param inv_p_l = 0.4u

**** end user architecture code
MM6 vc out 5uA+ VDD sg13_hv_pmos w=0.3u l=0.4u ng=1
x5 net2 vc vthl VDD 40uA- VSS comp_pmos
x7 net1 vthh vc VDD 40uA+ VSS comp_nmos
x2 10uA- vthl VDD vctrl VSS vthh voltage_mirror_pmos
x3 VDD net1 s VSS hv_inverter_6u5
x6 VDD net2 r VSS hv_inverter_6u5
x8 40uA+ 5uA+ VDD VSS 5uA- 10uA- 40uA- bias_current_generator
.ends

* expanding   symbol:  pulse_shaper_en.sym # of pins=9
** sym_path: /home/noah/Documents/freizeit/heichips/heichips26-voltage-controlled-resistor/macros/heichips26_vcr/macros/switched_capacitor/schematic/xschem/pulse_shaper_en.sym
** sch_path: /home/noah/Documents/freizeit/heichips/heichips26-voltage-controlled-resistor/macros/heichips26_vcr/macros/switched_capacitor/schematic/xschem/pulse_shaper_en.sch
.subckt pulse_shaper_en out1 nout1 VDD in VSS out2 nout2 en dis
*.PININFO out1:O nout1:O out2:O nout2:O in:I VSS:B VDD:B en:I dis:I
x7 VDD net1 net3 VSS low_th_inverter
x8 VDD net1 net2 VSS high_th_inverter
x10 VDD out1 nout1 VSS hv_inverter_40u
x11 VDD nout2 out2 VSS hv_inverter_40u
**** begin user architecture code

.include ../../../netlist/pex/hv_inverter_0u3_magic_pex_3.spice
.param w   = 0.3u
.param ng  = 1
.param n_ng = ng
.param n_w = {w*n_ng}
.param n_l = 0.45u
.param p_ng = ng
.param p_w = {1*w*p_ng}
.param p_l = 0.4u

**** end user architecture code
x1 VDD in net1 VSS hv_inverter_0u3
x5 VDD net2 out1 dis VSS hv_nor
x4 VDD net3 nout2 en VSS hv_nand
.ends

* expanding   symbol:  hv_binary_decoder4.sym # of pins=8
** sym_path: /home/noah/Documents/freizeit/heichips/heichips26-voltage-controlled-resistor/macros/heichips26_vcr/macros/switched_capacitor/schematic/xschem/hv_binary_decoder4.sym
** sch_path: /home/noah/Documents/freizeit/heichips/heichips26-voltage-controlled-resistor/macros/heichips26_vcr/macros/switched_capacitor/schematic/xschem/hv_binary_decoder4.sch
.subckt hv_binary_decoder4 msb lsb nout1 nout2 VDD VSS nout3 nout4
*.PININFO VDD:B VSS:B msb:I lsb:I nout1:O nout2:O nout3:O nout4:O
x3 VDD msb net1 VSS hv_inverter_40u
x7 VDD msb nout4 lsb VSS hv_nand
x9 VDD net1 nout2 lsb VSS hv_nand
x10 VDD lsb net2 VSS hv_inverter_40u
x11 VDD msb nout3 net2 VSS hv_nand
x8 VDD net1 nout1 net2 VSS hv_nand
.ends

* expanding   symbol:  hv_inverter_40u.sym # of pins=4
** sym_path: /home/noah/Documents/freizeit/heichips/heichips26-voltage-controlled-resistor/macros/heichips26_vcr/macros/switched_capacitor/schematic/xschem/hv_inverter_40u.sym
** sch_path: /home/noah/Documents/freizeit/heichips/heichips26-voltage-controlled-resistor/macros/heichips26_vcr/macros/switched_capacitor/schematic/xschem/hv_inverter_40u.sch
.subckt hv_inverter_40u VDD in out VSS
*.PININFO in:I VDD:B VSS:B out:O
MM2 out in VSS VSS sg13_hv_nmos w={n_w} l={n_l} ng={ng}
MM3 out in VDD VDD sg13_hv_pmos w={p_w} l={p_l} ng={ng}
**** begin user architecture code

.param w   = 10u
.param ng  = 4
.param n_ng = ng
.param n_w = {3u*n_ng}
.param n_l = 0.45u
.param p_ng = ng
.param p_w = {10u*p_ng}
.param p_l = 0.4u

**** end user architecture code
.ends

* expanding   symbol:  lvl_shift_up.sym # of pins=4
** sym_path: /home/noah/Documents/freizeit/heichips/heichips26-voltage-controlled-resistor/macros/heichips26_vcr/macros/switched_capacitor/schematic/xschem/lvl_shift_up.sym
** sch_path: /home/noah/Documents/freizeit/heichips/heichips26-voltage-controlled-resistor/macros/heichips26_vcr/macros/switched_capacitor/schematic/xschem/lvl_shift_up.sch
.subckt lvl_shift_up VDD in out VSS
*.PININFO in:I VDD:B VSS:B out:O
MM1 net1 in VSS VSS sg13_hv_nmos w={n_ng*n_w} l={n_l} ng={n_ng}
MM2 net1 in VDD VDD sg13_hv_pmos w={p_ng*p_w} l={p_l} ng={n_ng}
**** begin user architecture code

.include ../../../macros/switched_capacitor/schematic/xschem/hv_inverter_6u5.sym

.param n_ng = 2
.param n_w = 10u
.param n_l = 0.45u
.param p_ng = 2
.param p_w = 1u
.param p_l = 0.45u

**** end user architecture code
x4 VDD net1 out VSS hv_inverter_6u5
.ends

* expanding   symbol:  hv_nor4.sym # of pins=7
** sym_path: /home/noah/Documents/freizeit/heichips/heichips26-voltage-controlled-resistor/macros/heichips26_vcr/macros/switched_capacitor/schematic/xschem/hv_nor4.sym
** sch_path: /home/noah/Documents/freizeit/heichips/heichips26-voltage-controlled-resistor/macros/heichips26_vcr/macros/switched_capacitor/schematic/xschem/hv_nor4.sch
.subckt hv_nor4 VDD in1 out in2 VSS in3 in4
*.PININFO in1:I VDD:B VSS:B out:O in2:I in3:I in4:I
**** begin user architecture code

.param w   = 10u
.param ng  = 4
.param n_ng = ng
.param n_w = {3u*n_ng}
.param n_l = 0.45u
.param p_ng = ng
.param p_w = {10u*p_ng}
.param p_l = 0.4u

**** end user architecture code
MM2 out in3 VSS VSS sg13_hv_nmos w={n_w} l={n_l} ng={ng}
MM3 net3 in4 VDD VDD sg13_hv_pmos w={p_w} l={p_l} ng={ng}
MM1 out in4 VSS VSS sg13_hv_nmos w={n_w} l={n_l} ng={ng}
MM4 out in1 net1 VDD sg13_hv_pmos w={p_w} l={p_l} ng={ng}
MM5 out in2 VSS VSS sg13_hv_nmos w={n_w} l={n_l} ng={ng}
MM6 out in1 VSS VSS sg13_hv_nmos w={n_w} l={n_l} ng={ng}
MM7 net1 in2 net2 VDD sg13_hv_pmos w={p_w} l={p_l} ng={ng}
MM8 net2 in3 net3 VDD sg13_hv_pmos w={p_w} l={p_l} ng={ng}
.ends

* expanding   symbol:  hv_nor.sym # of pins=5
** sym_path: /home/noah/Documents/freizeit/heichips/heichips26-voltage-controlled-resistor/macros/heichips26_vcr/macros/switched_capacitor/schematic/xschem/hv_nor.sym
** sch_path: /home/noah/Documents/freizeit/heichips/heichips26-voltage-controlled-resistor/macros/heichips26_vcr/macros/switched_capacitor/schematic/xschem/hv_nor.sch
.subckt hv_nor VDD in1 out in2 VSS
*.PININFO in1:I VDD:B VSS:B out:O in2:I
**** begin user architecture code

.param w   = 10u
.param ng  = 4
.param n_ng = ng
.param n_w = {3u*n_ng}
.param n_l = 0.45u
.param p_ng = ng
.param p_w = {10u*p_ng}
.param p_l = 0.4u

**** end user architecture code
MM2 out in1 VSS VSS sg13_hv_nmos w={n_w} l={n_l} ng={ng}
MM3 net1 in2 VDD VDD sg13_hv_pmos w={p_w} l={p_l} ng={ng}
MM1 out in2 VSS VSS sg13_hv_nmos w={n_w} l={n_l} ng={ng}
MM4 out in1 net1 VDD sg13_hv_pmos w={p_w} l={p_l} ng={ng}
.ends

* expanding   symbol:  hv_rs-ff.sym # of pins=6
** sym_path: /home/noah/Documents/freizeit/heichips/heichips26-voltage-controlled-resistor/macros/heichips26_vcr/macros/switched_capacitor/schematic/xschem/hv_rs-ff.sym
** sch_path: /home/noah/Documents/freizeit/heichips/heichips26-voltage-controlled-resistor/macros/heichips26_vcr/macros/switched_capacitor/schematic/xschem/hv_rs-ff.sch
.subckt hv_rs-ff VDD nS Q nQ nR VSS
*.PININFO nS:I VDD:B VSS:B Q:O nR:I nQ:O
x4 VDD nS Q nQ VSS hv_nand
x5 VDD Q nQ nR VSS hv_nand
.ends

* expanding   symbol:  comp_pmos.sym # of pins=6
** sym_path: /home/noah/Documents/freizeit/heichips/heichips26-voltage-controlled-resistor/macros/heichips26_vcr/macros/switched_capacitor/schematic/xschem/comp_pmos.sym
** sch_path: /home/noah/Documents/freizeit/heichips/heichips26-voltage-controlled-resistor/macros/heichips26_vcr/macros/switched_capacitor/schematic/xschem/comp_pmos.sch
.subckt comp_pmos out - + VDD Ibias VSS
*.PININFO VDD:B VSS:B Ibias:I out:O +:I -:I
**** begin user architecture code

.param n_w = 1.2u
.param n_l = 1.5u
.param p_w = 2u
.param p_l = 0.4u
.param bcm = 1

**** end user architecture code
MM9 net1 Ibias VDD VDD sg13_hv_pmos w=bcm*p_w l=p_l ng=1
MM10 out Ibias VDD VDD sg13_hv_pmos w=bcm*p_w l=p_l ng=1
MM11 Ibias Ibias VDD VDD sg13_hv_pmos w=p_w l=p_l ng=1
MM12 net3 + net1 VDD sg13_hv_pmos w=p_w l=p_l ng=1
MM13 net2 - net1 VDD sg13_hv_pmos w=p_w l=p_l ng=1
MM14 net3 net2 VSS VSS sg13_hv_nmos w=n_w l=n_l ng=1
MM15 net2 net2 VSS VSS sg13_hv_nmos w=n_w l=n_l ng=1
MM16 out net3 VSS VSS sg13_hv_nmos w=n_w l=n_l ng=1
.ends

* expanding   symbol:  comp_nmos.sym # of pins=6
** sym_path: /home/noah/Documents/freizeit/heichips/heichips26-voltage-controlled-resistor/macros/heichips26_vcr/macros/switched_capacitor/schematic/xschem/comp_nmos.sym
** sch_path: /home/noah/Documents/freizeit/heichips/heichips26-voltage-controlled-resistor/macros/heichips26_vcr/macros/switched_capacitor/schematic/xschem/comp_nmos.sch
.subckt comp_nmos out - + VDD Ibias VSS
*.PININFO VDD:B VSS:B -:I +:I Ibias:I out:O
MM8 net2 + net3 VSS sg13_hv_nmos w=n_w l=n_l ng=1
MM6 net1 net1 VDD VDD sg13_hv_pmos w=p_w l=p_l ng=1
MM1 net2 net1 VDD VDD sg13_hv_pmos w=p_w l=p_l ng=1
MM3 net1 - net3 VSS sg13_hv_nmos w=n_w l=n_l ng=1
**** begin user architecture code

.param n_w = 1.2u
.param n_l = 1.5u
.param p_w = 2u
.param p_l = 0.4u

**** end user architecture code
MM2 out net2 VDD VDD sg13_hv_pmos w=p_w l=p_l ng=1
MM4 net3 Ibias VSS VSS sg13_hv_nmos w=2*n_w l=n_l ng=1
MM5 out Ibias VSS VSS sg13_hv_nmos w=2*n_w l=n_l ng=1
MM7 Ibias Ibias VSS VSS sg13_hv_nmos w=n_w l=n_l ng=1
.ends

* expanding   symbol:  voltage_mirror_pmos.sym # of pins=6
** sym_path: /home/noah/Documents/freizeit/heichips/heichips26-voltage-controlled-resistor/macros/heichips26_vcr/macros/switched_capacitor/schematic/xschem/voltage_mirror_pmos.sym
** sch_path: /home/noah/Documents/freizeit/heichips/heichips26-voltage-controlled-resistor/macros/heichips26_vcr/macros/switched_capacitor/schematic/xschem/voltage_mirror_pmos.sch
.subckt voltage_mirror_pmos Ibias nout VDD in VSS out
*.PININFO VDD:B VSS:B in:I out:O nout:O Ibias:I
**** begin user architecture code

.param n_w = 6u
.param n_l = 5u
.param p_w = 10u
.param p_l = 2u

**** end user architecture code
RR1 in Ibias 100.84k $SUB=VSS $[rhigh] w=0.5e-6 l=34e-6 b=0
MM4 net1 Ibias VDD VDD sg13_hv_pmos w=p_w l=p_l ng=1
MM5 out net1 VSS VSS sg13_hv_nmos w=n_w l=n_l ng=1
RR2 VSS nout 100.84k $SUB=VSS $[rhigh] w=0.5e-6 l=34e-6 b=0
RR3 out VDD 100.84k $SUB=VSS $[rhigh] w=0.5e-6 l=34e-6 b=0
MM2 net1 net1 VSS VSS sg13_hv_nmos w=n_w l=n_l ng=1
MM3 nout Ibias VDD VDD sg13_hv_pmos w=p_w l=p_l ng=1
MM6 Ibias Ibias VDD VDD sg13_hv_pmos w=1.9*p_w l=p_l ng=1
.ends

* expanding   symbol:  hv_inverter_6u5.sym # of pins=4
** sym_path: /home/noah/Documents/freizeit/heichips/heichips26-voltage-controlled-resistor/macros/heichips26_vcr/macros/switched_capacitor/schematic/xschem/hv_inverter_6u5.sym
** sch_path: /home/noah/Documents/freizeit/heichips/heichips26-voltage-controlled-resistor/macros/heichips26_vcr/macros/switched_capacitor/schematic/xschem/hv_inverter_6u5.sch
.subckt hv_inverter_6u5 VDD in out VSS
*.PININFO in:I VDD:B VSS:B out:O
MM2 out in VSS VSS sg13_hv_nmos w={n_w} l={n_l} ng={ng}
MM3 out in VDD VDD sg13_hv_pmos w={p_w} l={p_l} ng={ng}
**** begin user architecture code

.param ng  = 1
.param n_ng = ng
.param n_w = {2u*n_ng}
.param n_l = 0.45u
.param p_ng = ng
.param p_w = {6.5u*p_ng}
.param p_l = 0.4u

**** end user architecture code
.ends

* expanding   symbol:  bias_current_generator.sym # of pins=7
** sym_path: /home/noah/Documents/freizeit/heichips/heichips26-voltage-controlled-resistor/macros/heichips26_vcr/macros/switched_capacitor/schematic/xschem/bias_current_generator.sym
** sch_path: /home/noah/Documents/freizeit/heichips/heichips26-voltage-controlled-resistor/macros/heichips26_vcr/macros/switched_capacitor/schematic/xschem/bias_current_generator.sch
.subckt bias_current_generator 40uA+ 5uA+ VDD VSS 5uA- 10uA- 40uA-
*.PININFO 40uA+:O VSS:B VDD:B 40uA-:O 10uA-:O 5uA+:O 5uA-:O
x4 VDD net1 VSS current_reference_40uA
MM11 net1 net1 VDD VDD sg13_hv_pmos w=cm_p_w l=cm_p_l ng=1
MM12 40uA+ net1 VDD VDD sg13_hv_pmos w=cm_p_w l=cm_p_l ng=1
MM13 net2 net1 VDD VDD sg13_hv_pmos w=cm_p_w l=cm_p_l ng=1
MM14 net2 net2 VSS VSS sg13_hv_nmos w=cm_n_w l=cm_n_l ng=1
MM15 40uA- net2 VSS VSS sg13_hv_nmos w=cm_n_w l=cm_n_l ng=1
MM1 net3 net1 VDD VDD sg13_hv_pmos w=cm_p_w l=cm_p_l ng=1
MM2 net3 net3 VSS VSS sg13_hv_nmos w=4*cm_n_w l=cm_n_l ng=4
MM3 10uA- net3 VSS VSS sg13_hv_nmos w=cm_n_w l=cm_n_l ng=1
MM5 net4 net3 VSS VSS sg13_hv_nmos w=cm_n_w l=cm_n_l ng=1
MM25 net4 net4 VDD VDD sg13_hv_pmos w=2*cm_p_w l=cm_p_l ng=2
MM26 net5 net4 VDD VDD sg13_hv_pmos w=cm_p_w l=cm_p_l ng=1
MM27 5uA+ net4 VDD VDD sg13_hv_pmos w=cm_p_w l=cm_p_l ng=1
MM28 net5 net5 VSS VSS sg13_hv_nmos w=cm_n_w l=cm_n_l ng=2
MM29 5uA- net5 VSS VSS sg13_hv_nmos w=cm_n_w l=cm_n_l ng=1
**** begin user architecture code

.param cm_n_w = 6u
.param cm_n_l = 5u
.param cm_p_w = 10u
.param cm_p_l = 2u

**** end user architecture code
.ends

* expanding   symbol:  low_th_inverter.sym # of pins=4
** sym_path: /home/noah/Documents/freizeit/heichips/heichips26-voltage-controlled-resistor/macros/heichips26_vcr/macros/switched_capacitor/schematic/xschem/low_th_inverter.sym
** sch_path: /home/noah/Documents/freizeit/heichips/heichips26-voltage-controlled-resistor/macros/heichips26_vcr/macros/switched_capacitor/schematic/xschem/low_th_inverter.sch
.subckt low_th_inverter VDD vin vout VSS
*.PININFO vin:I VDD:B VSS:B vout:O
MM1 vout vin VSS VSS sg13_hv_nmos w={n_ng*n_w} l={n_l} ng={n_ng}
MM2 vout vin VDD VDD sg13_hv_pmos w={p_ng*p_w} l={p_l} ng={n_ng}
**** begin user architecture code

.param n_ng = 2
.param n_w = 1u
.param n_l = 0.45u
.param p_ng = 2
.param p_w = 1u
.param p_l = 0.4u

**** end user architecture code
.ends

* expanding   symbol:  high_th_inverter.sym # of pins=4
** sym_path: /home/noah/Documents/freizeit/heichips/heichips26-voltage-controlled-resistor/macros/heichips26_vcr/macros/switched_capacitor/schematic/xschem/high_th_inverter.sym
** sch_path: /home/noah/Documents/freizeit/heichips/heichips26-voltage-controlled-resistor/macros/heichips26_vcr/macros/switched_capacitor/schematic/xschem/high_th_inverter.sch
.subckt high_th_inverter VDD vin vout VSS
*.PININFO vin:I VDD:B VSS:B vout:O
**** begin user architecture code

.param n_ng = 2
.param n_w = 1u
.param n_l = 0.45u
.param p_ng = 2
.param p_w = 10u
.param p_l = 0.4u

**** end user architecture code
MM1 vout vin VSS VSS sg13_hv_nmos w={n_ng*n_w} l={n_l} ng={p_ng}
MM2 vout vin VDD VDD sg13_hv_pmos w={p_ng*p_w} l={p_l} ng={p_ng}
.ends

* expanding   symbol:  hv_inverter_0u3.sym # of pins=4
** sym_path: /home/noah/Documents/freizeit/heichips/heichips26-voltage-controlled-resistor/macros/heichips26_vcr/macros/switched_capacitor/schematic/xschem/hv_inverter_0u3.sym
** sch_path: /home/noah/Documents/freizeit/heichips/heichips26-voltage-controlled-resistor/macros/heichips26_vcr/macros/switched_capacitor/schematic/xschem/hv_inverter_0u3.sch
.subckt hv_inverter_0u3 VDD in out VSS
*.PININFO in:I VDD:B VSS:B out:O
MM2 out in VSS VSS sg13_hv_nmos w={n_w} l={n_l} ng={ng}
MM3 out in VDD VDD sg13_hv_pmos w={p_w} l={p_l} ng={ng}
**** begin user architecture code

.param w   = 0.3u
.param ng  = 1
.param n_ng = ng
.param n_w = {w*n_ng}
.param n_l = 0.45u
.param p_ng = ng
.param p_w = {1*w*p_ng}
.param p_l = 0.4u

**** end user architecture code
.ends

* expanding   symbol:  hv_nand.sym # of pins=5
** sym_path: /home/noah/Documents/freizeit/heichips/heichips26-voltage-controlled-resistor/macros/heichips26_vcr/macros/switched_capacitor/schematic/xschem/hv_nand.sym
** sch_path: /home/noah/Documents/freizeit/heichips/heichips26-voltage-controlled-resistor/macros/heichips26_vcr/macros/switched_capacitor/schematic/xschem/hv_nand.sch
.subckt hv_nand VDD in1 out in2 VSS
*.PININFO in1:I VDD:B VSS:B out:O in2:I
**** begin user architecture code

.param w   = 10u
.param ng  = 4
.param n_ng = ng
.param n_w = {3u*n_ng}
.param n_l = 0.45u
.param p_ng = ng
.param p_w = {10u*p_ng}
.param p_l = 0.4u

**** end user architecture code
MM2 out in1 net1 VSS sg13_hv_nmos w={n_w} l={n_l} ng={ng}
MM3 out in2 VDD VDD sg13_hv_pmos w={p_w} l={p_l} ng={ng}
MM1 net1 in2 VSS VSS sg13_hv_nmos w={n_w} l={n_l} ng={ng}
MM4 out in1 VDD VDD sg13_hv_pmos w={p_w} l={p_l} ng={ng}
.ends

* expanding   symbol:  current_reference_40uA.sym # of pins=3
** sym_path: /home/noah/Documents/freizeit/heichips/heichips26-voltage-controlled-resistor/macros/heichips26_vcr/macros/switched_capacitor/schematic/xschem/current_reference_40uA.sym
** sch_path: /home/noah/Documents/freizeit/heichips/heichips26-voltage-controlled-resistor/macros/heichips26_vcr/macros/switched_capacitor/schematic/xschem/current_reference_40uA.sch
.subckt current_reference_40uA VDD iout VSS
*.PININFO VSS:B VDD:B iout:B
MM8 net2 net2 VSS VSS sg13_hv_nmos w=n_w l=n_l ng=1
MM6 net2 net1 VDD VDD sg13_hv_pmos w=p_w l=p_l ng=1
MM1 net1 net1 VDD VDD sg13_hv_pmos w=p_w l=p_l ng=1
MM3 net1 net2 net3 VSS sg13_hv_nmos w=n_w l=n_l ng=1
RR2 net4 VSS 2.8735k $SUB=VSS $[rppd] w=2e-6 l=21.9e-6 b=0
MM2 net1 net2 net3 VSS sg13_hv_nmos w=n_w l=n_l ng=1
MM4 net1 net2 net3 VSS sg13_hv_nmos w=n_w l=n_l ng=1
MM5 net1 net2 net3 VSS sg13_hv_nmos w=n_w l=n_l ng=1
MM7 iout net2 VSS VSS sg13_hv_nmos w=n_w l=n_l ng=1
RR3 net3 net4 5.0278k $SUB=VSS $[rsil] w=0.5e-6 l=365e-6
**** begin user architecture code

.param n_w = 6u
.param n_l = 5u
.param p_w = 10u
.param p_l = 2u

**** end user architecture code
.ends
